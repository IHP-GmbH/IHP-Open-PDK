* SVaricap LVS testcase: one small and one large CMOS5L device.
.SUBCKT svaricap
Csmall G1_small W_small G2_small sub! sg13_hv_svaricap w=3.74u l=0.3u Nx=1
Clarge G1_large W_large G2_large sub! sg13_hv_svaricap w=9.74u l=0.8u Nx=1
.ENDS svaricap
