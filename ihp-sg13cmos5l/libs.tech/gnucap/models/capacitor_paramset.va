//******************************************************************************
//                                                                             *
// Copyright 2026 IHP PDK Authors                                              *
//                                                                             *
// Licensed under the Apache License, Version 2.0 (the "License");             *
// you may not use this file except in compliance with the License.            *
// You may obtain a copy of the License at                                     *
//                                                                             *
//     https://www.apache.org/licenses/LICENSE-2.0                             *
//                                                                             *
// Unless required by applicable law or agreed to in writing, software         *
// distributed under the License is distributed on an "AS IS" BASIS,           *
// WITHOUT WARRANTIES OR CONDITIONS OF ANY KIND, either express or implied.    *
// See the License for the specific language governing permissions and         *
// limitations under the License.                                              *
//                                                                             *
//******************************************************************************

// Verilog-A capacitor paramsets for SG13CMOS5L.
//
// Derived from the SG13G2 models/capacitor_paramset.va ((c) Lukas Deutz 2026),
// reduced to the one capacitor this PDK has. SG13G2's file also carries
// cparasitic, cmim_core and the reserved cmim/rfcmim slots, all of which need
// devices SG13CMOS5L does not have (no cap_cmim, no cap_rfcmim, no cparasitic),
// so it is not symlinked and `include "capacitor.va"` is not needed here: that
// header only supplies the sp_capacitor primitive those paramsets decompose
// onto, and cmomi does not use it.
//
// The include below resolves to this PDK's own Metal1..Metal4 model because
// models/Makefile puts $(IHP_VERILOG_DIR)/cap_cmomi on the modelgen include
// path and $(IHP_VERILOG_DIR) is this repository's libs.tech/verilog-a. The
// SG13G2 model of the same name is not reachable: of the four directories on
// that path, only this one holds a cap_cmomi.va, and the other three
// (models/, and the r3_cmc and psp103 symlinks into SG13G2) do not.
//
// Worth being precise about what that buys, because whether it matters depends
// on what the sibling tree currently holds. Besides these parameter bounds and
// the dropped Nlay = 5 coefficient branch, this PDK's copy corrects two things
// in the shipped SG13G2 model: it bills the coupled rows the cell draws rather
// than one fewer, and its single-side feed term is fitted on the drawn cell
// instead of transferred. Both corrections apply to the g2 twin, which draws
// the same cell, and are made on its own branch. Until that lands, including
// the wrong file WOULD change numbers here; once it does, the two are
// numerically identical again for Nlay <= 4. Either way the include path is
// right by construction, not because a test would catch it being wrong.

`pragma modelgen nogen-module
`include "cap_cmomi.va"
`include "cap_cmomf.va"

//******************************************************************************
// cmomi paramset (interdigitated MoM capacitor)
//******************************************************************************

// cap_cmomi is a self-contained behavioural RF model (its own series/shunt
// equivalent circuit) rather than a parallel-plate primitive, so it is NOT
// decomposed onto sp_capacitor. This paramset wraps the behavioural module
// cap_cmomi (shared source ../../verilog-a/cap_cmomi/cap_cmomi.va, byte-for-byte
// the code the ngspice OSDI build uses) and pins the named-device defaults,
// exactly as `paramset rsil r3_cmc` wraps the resistor CMC primitive.
//
// The bounds are this PDK's: mmin and mmax are [1:4] and mmax defaults to 4,
// against SG13G2's [1:8] and 5. They are not cosmetic. SG13CMOS5L stops at
// Metal4, so an mmax of 5 has no metal to build on, and the module's own
// parameter declaration rejects it.
//
// cap_cmomi has no characterised corner/mismatch spread yet (it returns nominal
// in every corner, pending silicon), so there are no corner cross-references
// here. The mm_ok selector is declared (mm_ok = 0, the no-mismatch case) but not
// mapped, since cap_cmomi has no mm_ok port, so it is an accepted-but-unused
// selector. It reserves the mm_ok = 1 overload slot: when the spread is
// characterised, add an mm_ok = 1 from [1:1] variant the way the resistor
// paramsets do.
//
// Terminals PLUS, MINUS, SUB are inherited from the module; tie SUB to ground
// for the classic 2-terminal use (the ngspice wrapper subckt and the gnucap
// testbench both do this).
paramset cmomi cap_cmomi
    parameter real    w        = 5e-6 from (0.0:inf);
    parameter real    l        = 5e-6 from (0.0:inf);
    parameter integer mmin     = 1    from [1:4];
    parameter integer mmax     = 4    from [1:4];
    parameter integer feed     = 2    from [0:2];
    parameter integer subblock = 0    from [0:1];
    parameter integer mm_ok    = 0    from [0:0];
    .w        = w;
    .l        = l;
    .mmin     = mmin;
    .mmax     = mmax;
    .feed     = feed;
    .subblock = subblock;
endparamset

//******************************************************************************
// cmomf paramset (metal fringe MoM capacitor)
//******************************************************************************

// The fringe sibling of cmomi, over the behavioural module cap_cmomf (shared
// source ../../verilog-a/cap_cmomf/cap_cmomf.va, byte-for-byte the code the
// ngspice OSDI build uses). Like cmomi it is not decomposed onto sp_capacitor:
// it carries its own expression rather than being a parallel-plate primitive.
//
// There is no feed parameter: the interdigitated device's feed topology has no
// analogue in a finger comb. rfmodel and subscale select the equivalent circuit,
// see the header of cap_cmomf.va. Terminals PLUS, MINUS, SUB are inherited from
// the module; tie SUB to ground as for cmomi.
//
// The corner and mismatch factors of the module are not mapped here: as for
// cmomi there are no corner cross-references, and mm_ok is declared from [0:0]
// and left unmapped to reserve the mm_ok = 1 overload slot.
paramset cmomf cap_cmomf
    parameter real    w        = 5e-6 from (0.0:inf);
    parameter real    l        = 5e-6 from (0.0:inf);
    parameter integer mmin     = 1    from [1:4];
    parameter integer mmax     = 4    from [1:4];
    parameter integer subblock = 0    from [0:1];
    parameter integer rfmodel  = 0    from [0:1];
    parameter real    subscale = 1.0  from [0.0:inf);
    parameter integer mm_ok    = 0    from [0:0];
    .w        = w;
    .l        = l;
    .mmin     = mmin;
    .mmax     = mmax;
    .subblock = subblock;
    .rfmodel  = rfmodel;
    .subscale = subscale;
endparamset
