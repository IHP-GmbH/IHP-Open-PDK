// load model plugins
load vams/vsine.so
load ../../../plugins/models/capacitor_paramset.so

module tb_cap_cmomi(out1);
    // external port for probing
    inout out1;
    electrical out1;
    // internal nodes
    electrical in1;
    ground gnd;
    // cmomi is the SG13CMOS5L MoM-cap paramset (over the behavioural cap_cmomi
    // module) in capacitor_paramset.so. It is 3-terminal (PLUS, MINUS, SUB); tie
    // SUB to ground for the classic 2-terminal use, exactly as the ngspice
    // subckt does.
    //
    // mmax is 4, not the 5 the SG13G2 testbench uses: this PDK stops at Metal4.
    // That single digit is what makes this a SG13CMOS5L measurement rather than
    // a rerun of SG13G2's, so the reference output here is regenerated and not
    // symlinked like the resistor and MOS ones.
    vsine #(.mag(1), .dc(0.0)) V1(in1, gnd);
    cmomi #(.w(5u), .l(5u), .mmin(1), .mmax(4), .feed(2)) C1(out1, in1, gnd);
    resistor #(.r(100k)) R1(out1, gnd);
endmodule
