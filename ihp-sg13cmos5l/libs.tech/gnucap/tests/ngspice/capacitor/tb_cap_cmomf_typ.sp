* tb_cap_cmomf_typ -- ngspice cross-validation of the gnucap tb_cap_cmomf_typ.gc
*
* Copyright 2026 IHP PDK Authors
* Licensed under the Apache License, Version 2.0 (the "License").
*
* Same testbench as the gnucap tb_cap_cmomf_typ.gc: a high-pass R-C whose -3 dB
* corner f_3dB = 1/(2*pi*R*C) recovers the low-frequency capacitance of the
* metal fringe MoM cap.  Running it here through ngspice cross-checks the two
* simulators against each other on the same device.
*   Device: 5 um x 5 um, Metal1..Metal4.
*
* Unlike every other test in this suite there is no SG13G2 reference to
* symlink: SG13G2 reserved the cap_cmomf name but has never shipped the device,
* so both the testbench and the ref/ output beside it are this PDK's own.
*
* Same geometry as tb_cap_cmomi_typ.sp on purpose, so the two are directly
* comparable.  The fringe cap is the denser of the pair here, 1.287 fF/um2
* against 1.09, and its corner sits near 49.5 MHz where cmomi's sits near
* 97.6 MHz.
*
* The cap_cmomf OSDI is loaded by the directory .spiceinit, which is a real
* file here rather than the usual symlink into SG13G2 precisely because that
* shared init knows nothing about this device.  cap_cmomf.lib (the wrapper
* subckt) is resolved through the model sourcepath set there.  Both come from
* the INSTALLED PDK at $PDK_ROOT/$PDK, not from this working tree, and the OSDI
* is a tracked binary regenerated by hand with
* libs.tech/verilog-a/openvaf-compile-va.sh.  No build rule ties it to
* cap_cmomf.va, so unlike the gnucap plugin it does not rebuild when the source
* changes.
.include "cap_cmomf.lib"

* high-pass R-C: V drives in1, cap in1 -> out1, R out1 -> ground
V1 in1 0 dc 0 ac 1
R1 out1 0 100k
XC1 out1 in1 cap_cmomf w=5.0u l=5.0u mmin=1 mmax=4

.control
set wr_vecnames
set wr_singlescale
* run ac (matches the .gc: dec, 1000 pts/decade, 1 MHz .. 1 GHz)
ac dec 1000 1e6 1e9
* magnitude at the probe node
let mag1=abs(out1)
* measure the -3 dB cutoff frequency
meas ac freq1_at when mag1 = 0.707
* approximate capacitance from the cutoff frequency (R = 100k)
let C1 = 1/(2*PI*freq1_at*1e+5)
print C1
wrdata check/tb_cap_cmomf_typ.sp.out abs(out1)
.endc
.end
