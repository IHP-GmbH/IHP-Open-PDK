* tb_cap_cmomi_typ -- ngspice cross-validation of the gnucap tb_cap_cmomi_typ.gc
*
* Copyright 2026 IHP PDK Authors
* Licensed under the Apache License, Version 2.0 (the "License").
*
* Same testbench as the gnucap tb_cap_cmomi_typ.gc: a high-pass R-C whose -3 dB
* corner f_3dB = 1/(2*pi*R*C) recovers the low-frequency capacitance of the MoM
* cap.  Running it here through ngspice cross-checks the two simulators against
* each other on the same device.
*   Device: 5 um x 5 um, Metal1..Metal4, feed = double.
*
* This is the one device in the suite whose SG13G2 reference data does not
* transfer, which is why the ref/ here is regenerated rather than symlinked.
* Two things separate the two runs.  The testbench differs: SG13G2 instantiates
* mmax = 5 where this one uses mmax = 4.  And the models now differ as well:
* this PDK now bills the coupled rows the cell draws, floor(w/0.89), and charges
* the opposite-side (double) feed term.  With mmax = 4, the corrected row count
* and that feed term, the corner sits near 75.4 MHz -> C ~ 21.11 fF.  The
* SG13G2 mmax = 5 twin now sits lower in frequency (larger C), so unlike before
* the two runs are distinguishable.
*
* The cap_cmomi OSDI is loaded by the directory .spiceinit; cap_cmomi.lib (the
* 2-terminal wrapper subckt, which ties SUB to ground) is resolved through the
* model sourcepath set there.  Both come from the INSTALLED PDK at
* $PDK_ROOT/$PDK, not from this working tree, and the OSDI is a tracked binary
* regenerated by hand with libs.tech/verilog-a/openvaf-compile-va.sh.  No build
* rule ties it to cap_cmomi.va, so unlike the gnucap plugin it does not rebuild
* when the source changes.
.include "cap_cmomi.lib"

* high-pass R-C: V drives in1, cap in1 -> out1, R out1 -> ground
V1 in1 0 dc 0 ac 1
R1 out1 0 100k
XC1 out1 in1 cap_cmomi w=5.0u l=5.0u mmin=1 mmax=4 feed=double

.control
set wr_vecnames
set wr_singlescale
* run ac (matches the .gc: dec, 1000 pts/decade, 1 MHz .. 1 GHz)
ac dec 1000 1e6 1e9
* magnitude at the probe node
let mag1=abs(out1)
* measure the -3 dB cutoff frequency
meas ac freq1_at when mag1 = 0.707
* approximate capacitance from the cutoff frequency (R = 100k)
let C1 = 1/(2*PI*freq1_at*1e+5)
print C1
wrdata check/tb_cap_cmomi_typ.sp.out abs(out1)
.endc
.end
