*==========================================================================
* Copyright 2026 IHP PDK Authors
*
* Licensed under the Apache License, Version 2.0 (the "License");
* you may not use this file except in compliance with the License.
* You may obtain a copy of the License at
*
*    https://www.apache.org/licenses/LICENSE-2.0
*
* Unless required by applicable law or agreed to in writing, software
* distributed under the License is distributed on an "AS IS" BASIS,
* WITHOUT WARRANTIES OR CONDITIONS OF ANY KIND, either express or implied.
* See the License for the specific language governing permissions and
* limitations under the License.
* SPDX-License-Identifier: Apache-2.0
*==========================================================================
* Two caps declared against the three-cap hierarchical layout, run in deep mode.
*
* This is chain_missing's perturbation applied to cap_cmomf_hier.gds: a device
* present in the layout and absent from the schematic. The flat case catches it
* on the comparison. This one fails on the empty-extraction guard in
* sg13cmos5l.lvs, which runs after a comparison that had nothing left to compare
* and returned true.
*
* What happens in deep mode: every cap here sits in a sub-cell with no net
* crossing that cell's boundary, and the layout netlist comes out empty. This is
* the same behaviour cap_cmomi shows on the same construction, recorded in the
* cap_cmomi section of testing/README.md and in
* https://github.com/IHP-GmbH/ihp-sg13cmos5l/issues/91. Two devices sharing one
* extractor and differing only in their marker behaving identically is the first
* evidence that the hole belongs to neither of them.
*
* The wired counterpart is the case that makes this one mean something: same
* hierarchy, one Metal4 route in the top cell, and deep extracts both caps. The
* cause is not diagnosed here either.
*
* The layout is the unit testcase's, referenced across rather than copied, so the
* flat and deep runs cannot drift apart. That unit case runs the same layout in
* flat mode and must pass.
*
* Expected to FAIL, on the guard rather than on the comparison itself.
.SUBCKT cap_cmomf_hier
C1 P1 M1 cap_cmomf w=5e-06 l=5e-06 mmin=1 mmax=4
C2 P2 M2 cap_cmomf w=5e-06 l=5e-06 mmin=1 mmax=4
.ENDS cap_cmomf_hier
