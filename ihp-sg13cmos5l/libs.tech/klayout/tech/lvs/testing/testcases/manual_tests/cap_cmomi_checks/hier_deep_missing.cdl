*==========================================================================
* Copyright 2026 IHP PDK Authors
*
* Licensed under the Apache License, Version 2.0 (the "License");
* you may not use this file except in compliance with the License.
* You may obtain a copy of the License at
*
*    https://www.apache.org/licenses/LICENSE-2.0
*
* Unless required by applicable law or agreed to in writing, software
* distributed under the License is distributed on an "AS IS" BASIS,
* WITHOUT WARRANTIES OR CONDITIONS OF ANY KIND, either express or implied.
* See the License for the specific language governing permissions and
* limitations under the License.
* SPDX-License-Identifier: Apache-2.0
*==========================================================================
* Two caps declared against the three-cap hierarchical layout, run in deep mode.
*
* This is chain_missing's perturbation applied to cap_cmomi_hier.gds: a device
* present in the layout and absent from the schematic. Case 2 catches it on the
* comparison. This one fails on the empty-extraction guard, which runs after a
* comparison that had nothing left to compare and returned true; before that guard
* existed the run PASSED, which is what makes this case worth keeping.
*
* What happens in deep mode: every cap here sits in a sub-cell with no net
* crossing that cell's boundary, and the layout netlist comes out empty. compare
* is then left with no pair to compare and returns true, which is how an empty
* run used to be reported as a match. Extraction is not what fails: the .lvsdb
* still carries the cap_cmomi device abstract with its mim_top/mim_btm terminal
* geometry, identical to the flat run's, and no marker is ever rejected.
*
* This is recorded, not explained. The cause was not diagnosed. What was measured,
* and only this:
*   - not the hierarchy. Case 13 is this same shape with one Metal4 strap drawn in
*     the top cell, so a single net crosses a boundary, and deep extracts both
*     caps, matches the correct netlist and fails one missing a device.
*   - not an isolated cap by itself. Add a third cap, in its own cell and
*     connected to nothing, beside two strapped ones, and all three still extract.
*   - not simplify (--no_simplify), not --top_lvl_pins, not a missing --topcell.
*   - not helped by naming: a hierarchical schematic declaring a subcircuit named
*     after the sub-cell leaves the layout netlist just as empty.
*
* Nothing above establishes that this is cap_cmomi-specific, so do not read it
* that way. Note for whoever tries to settle it with another device: run_lvs.py
* writes the extracted .cir before align, so a run that aborts there still leaves
* a plausible-looking netlist behind. Read the verdict line, not the artifacts.
*
* What the guard changed, and what it did not. The deck now refuses to call an
* empty layout netlist a match, so this case is reported instead of passing. The
* extraction hole itself is untouched: deep mode still cannot verify this layout,
* it just can no longer bless it. ihp-sg13g2 at the pinned commit has no such
* guard and still reports a match on the same layout with its own deck.
* See IHP-GmbH/ihp-sg13cmos5l#91.
*
* The layout is the unit testcase's, referenced across rather than copied, so the
* two cases cannot drift apart. That unit case runs the same layout in flat mode
* and must pass; this one records what the same layout does in deep.
*
* Expected to FAIL, on the guard rather than on the comparison itself.
.SUBCKT cap_cmomi_hier
C1 P1 M1 cap_cmomi w=5e-06 l=5e-06 mmin=1 mmax=4 feed=double
C2 P2 M2 cap_cmomi w=5e-06 l=5e-06 mmin=1 mmax=4 feed=double
.ENDS cap_cmomi_hier
