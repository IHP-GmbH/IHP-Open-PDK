*==========================================================================
* Copyright 2026 IHP PDK Authors
*
* Licensed under the Apache License, Version 2.0 (the "License");
* you may not use this file except in compliance with the License.
* You may obtain a copy of the License at
*
*    https://www.apache.org/licenses/LICENSE-2.0
*
* Unless required by applicable law or agreed to in writing, software
* distributed under the License is distributed on an "AS IS" BASIS,
* WITHOUT WARRANTIES OR CONDITIONS OF ANY KIND, either express or implied.
* See the License for the specific language governing permissions and
* limitations under the License.
* SPDX-License-Identifier: Apache-2.0
*==========================================================================
* Two caps in series, each in its own sub-cell, joined by a top-level strap.
*
* The deep-mode counterpart of case 12, and the reason both exist. Case 12 runs
* a hierarchy where nothing crosses a cell boundary and must fail; this one is
* the same hierarchy with one Metal4 strap drawn in the top cell, and must pass.
* Together they say what actually triggers the hole: not sub-cells, but a
* sub-circuit that ends up with no pins.
*
* Without a passing deep case the suite would be blind in the direction that
* matters. Case 12 only asserts a failure, and deep extraction breaking outright
* would still produce a failure, so case 12 alone would stay green while every
* hierarchical user was broken.
*
* Layout generated by create_cap_cmomi_testcases.py.
.SUBCKT cmomi_hier_wired
C1 A  N1 cap_cmomi w=5e-06 l=5e-06 mmin=1 mmax=4 feed=double
C2 N1 B  cap_cmomi w=5e-06 l=5e-06 mmin=1 mmax=4 feed=double
.ENDS cmomi_hier_wired
