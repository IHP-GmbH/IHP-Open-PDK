*==========================================================================
* Copyright 2024 IHP PDK Authors
*
* Licensed under the Apache License, Version 2.0 (the "License");
* you may not use this file except in compliance with the License.
* You may obtain a copy of the License at
*
*    https://www.apache.org/licenses/LICENSE-2.0
*
* Unless required by applicable law or agreed to in writing, software
* distributed under the License is distributed on an "AS IS" BASIS,
* WITHOUT WARRANTIES OR CONDITIONS OF ANY KIND, either express or implied.
* See the License for the specific language governing permissions and
* limitations under the License.
* SPDX-License-Identifier: Apache-2.0
*==========================================================================
* CMOS5L pnpMPA test structure - lateral PNP without nBuLay isolation

.subckt pnpMPA_lvs VDD VSS PAD
*.PININFO VDD:B VSS:B PAD:B
RR2 VSS sub! ptap1 A=6.084e-13 P=3.12e-06
QQ1 sub! PAD VDD pnpMPA a=2e-12 p=6e-06 m=1
.ends
