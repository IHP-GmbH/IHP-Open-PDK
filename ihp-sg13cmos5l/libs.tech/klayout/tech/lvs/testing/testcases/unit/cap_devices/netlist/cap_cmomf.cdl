*==========================================================================
* Copyright 2026 IHP PDK Authors
*
* Licensed under the Apache License, Version 2.0 (the "License");
* you may not use this file except in compliance with the License.
* You may obtain a copy of the License at
*
*    https://www.apache.org/licenses/LICENSE-2.0
*
* Unless required by applicable law or agreed to in writing, software
* distributed under the License is distributed on an "AS IS" BASIS,
* WITHOUT WARRANTIES OR CONDITIONS OF ANY KIND, either express or implied.
* See the License for the specific language governing permissions and
* limitations under the License.
* SPDX-License-Identifier: Apache-2.0
*==========================================================================
* Covers both top-metal orientations of cap_cmomf on the cmos5l Metal1-Metal4
* stack, and a stack that does not reach the top metal. The finger direction
* alternates per layer, so the metal that carries the PLUS/MINUS pins depends
* on how many layers the stack has:
*   C1 = M1..M4 -> the top metal's fingers run along X, pins land on the left
*                  connecting bar and the top edge
*   C2 = M2..M4 -> the top metal's fingers run along Y, pins land on the left
*                  edge and the top connecting bar
*   C3 = M1..M3 -> same orientation as C1 but the ports come off Metal3, which
*                  is the only way the m3 port path of the extractor is reached
.SUBCKT cap_cmomf
C1 P1 M1 cap_cmomf w=5e-06 l=5e-06
C2 P2 M2 cap_cmomf w=5e-06 l=5e-06
C3 P3 M3 cap_cmomf w=5e-06 l=5e-06
.ENDS cap_cmomf
