*==========================================================================
* Copyright 2026 IHP PDK Authors
*
* Licensed under the Apache License, Version 2.0 (the "License");
* you may not use this file except in compliance with the License.
* You may obtain a copy of the License at
*
*    https://www.apache.org/licenses/LICENSE-2.0
*
* Unless required by applicable law or agreed to in writing, software
* distributed under the License is distributed on an "AS IS" BASIS,
* WITHOUT WARRANTIES OR CONDITIONS OF ANY KIND, either express or implied.
* See the License for the specific language governing permissions and
* limitations under the License.
* SPDX-License-Identifier: Apache-2.0
*==========================================================================
* cap_cmomi instanced through a cell hierarchy.
*
* The layout puts one cap in a sub-cell that is instanced twice, plus a third
* cap placed directly in the top cell. All three carry the same Recog.mom
* marker geometry. Layout generated by create_cap_cmomi_testcases.py.
*
* Runs in the default flat mode, so the hierarchy is flattened before the
* extractor sees any geometry. What this asserts is therefore that a
* hierarchical GDS flattens to three markers and yields three devices on three
* separate net pairs: repeated marker geometry does not collide or merge, and
* the placements are not collapsed into one device. Counting per instance
* definition instead of per placement is a deep-mode failure and is not what
* this case can catch.
*
* Deep mode is deliberately NOT run here, and not because it is uninteresting:
* this same layout in deep mode produces no circuit at all and then matches any
* schematic, so a deep unit testcase would pass without testing anything. That
* is recorded as case 12 of the cap_cmomi checks suite, which runs this layout
* in deep mode against a netlist that is wrong on purpose, and see
* IHP-GmbH/ihp-sg13cmos5l#91.
.SUBCKT cap_cmomi_hier
C1 P1 M1 cap_cmomi w=5e-06 l=5e-06 mmin=1 mmax=4 feed=double
C2 P2 M2 cap_cmomi w=5e-06 l=5e-06 mmin=1 mmax=4 feed=double
C3 P3 M3 cap_cmomi w=5e-06 l=5e-06 mmin=1 mmax=4 feed=double
.ENDS cap_cmomi_hier
