// ---------------------------------------------------------------------------
// Copyright 2026 IHP PDK Authors
//
// Licensed under the Apache License, Version 2.0 (the "License");
// you may not use this file except in compliance with the License.
// You may obtain a copy of the License at
//
//     https://www.apache.org/licenses/LICENSE-2.0
//
// Unless required by applicable law or agreed to in writing, software
// distributed under the License is distributed on an "AS IS" BASIS,
// WITHOUT WARRANTIES OR CONDITIONS OF ANY KIND, either express or implied.
// See the License for the specific language governing permissions and
// limitations under the License.
// SPDX-License-Identifier: Apache-2.0
// ---------------------------------------------------------------------------
//
// cap_cmomf - metal fringe (finger) MoM capacitor, ihp-sg13cmos5l M1..M4
//
// *** FITTED TO EM SIMULATION. NOT VALIDATED ON SILICON. ***
//
// Equivalent circuit, one substrate branch per plate so that the device is
// symmetric and its orientation has no electrical meaning:
//
//        Rs/2  Ls/2      C      Ls/2  Rs/2
//   PLUS --/\/\--uuu--+---||---+--uuu--/\/\-- MINUS
//     |                                         |
//     Cp                                        Cp
//     |                                         |
//     rsub                                      rsub
//     |                                         |
//    SUB ------------------------------------- SUB
//
// rfmodel = 0 (default) leaves C, its temperature coefficient and the leak.
// All internal nodes collapse, so the cost per instance stays that of a
// capacitor. rfmodel = 1 adds series R and L, the dielectric loss and the
// substrate branches.
//
// CAPACITANCE
//     C = dens(mmin, mmax) * (l - 2 rim) * (w - 2 rim)
//
// The outer rim of the drawn device holds feeds and bars rather than comb, so
// C does not scale with the drawn area. The earlier C = areacap * l * w read
// 13 to 62 % high against EM, most on small devices. dens and rim are fitted
// to Palace results (order 3, drawn geometry), see README.md in this
// directory, which also says how good each number is:
//
//     Metal1..4   1.107 fF/um^2   0.207 um   max error 2.5 %
//     Metal2..4   0.852           0.193      max error 4.5 %
//     Metal3..4   0.504           0.121      max error 8 %
//
// The other stacks have no converged EM point. Their densities are estimates
// from RC extraction and rim is 0.20 um.
//
// The same expression is duplicated, on purpose, in the PCell
// (cap_cmomf_code.py), the xschem symbol (cap_cmomf.sym), the Magic generator
// (ihp-sg13cmos5l-cap.tcl) and the PCell sweep (cap_cmomf_sweep.py), so the
// drawn C label and the simulated value can never disagree. All of them have
// to be changed together.
//
// LIMITS
//   - No value here is a silicon value. Corner, temperature, dielectric loss
//     and mismatch numbers are estimates from the process specification and
//     from publications on other processes, see README.md.
//   - rfmodel = 1 has one series R anchor, a 25 um x 10 um Metal2..4 device.
//     Other sizes are extrapolated by the closed form below.
//   - The dielectric term is a series R that is correct at fref and too small
//     below it. There is no dielectric absorption.
//   - Finger parity is not modelled. An even finger count puts both outer
//     fingers on one net, and such a device reads 7 to 14 % under the fit on
//     narrow cells.
//
// Terminals:
//   PLUS   - plate 1 (left edge of the drawn device)
//   MINUS  - plate 2 (top edge of the drawn device)
//   SUB    - substrate. The wrapper subckt ties it to node 0, so the device
//            stays 2-terminal for schematics and LVS; rsub stands for the
//            path to the real substrate tie.
//
// Instance parameters:
//   w        - width  [m], the Y extent of the drawn device (default 5 um)
//   l        - length [m], the X extent of the drawn device (default 5 um)
//   mmin     - bottom metal index (1 = M1 .. 4 = M4)  (default 1)
//   mmax     - top metal index    (1 = M1 .. 4 = M4)  (default 4)
//   subblock - 0|1 substrate-isolation block (layout/LVS only, no electrical
//              effect; accepted for interface parity with cap_cmomi)
//   rfmodel  - 0: capacitance only, 1: full equivalent circuit (default 0)
//   subscale - factor on Cp (default 1). About 0.57 inside an array, where
//              neighbours screen the plates from the substrate.
//   cscale   - corner factor on C (default 1), set by cornerCAP.lib
//   rscale   - corner factor on the metal R (default 1), set by cornerCAP.lib
//   mmz      - standard normal deviate for local mismatch (default 0)
//
// Model parameters: tc1, tcr, tand, fref, rsub, tnom, see below.
// ---------------------------------------------------------------------------

`include "disciplines.vams"
`include "constants.vams"

module cap_cmomf(PLUS, MINUS, SUB);

    inout PLUS, MINUS, SUB;
    electrical PLUS, MINUS, SUB;
    electrical na, nb, np, nm;

    // ---- instance parameters -------------------------------------------------
    (* type = "instance", units = "m", desc = "width (Y extent)" *)
    parameter real    w        = 5e-6 from (0.0:inf);
    (* type = "instance", units = "m", desc = "length (X extent)" *)
    parameter real    l        = 5e-6 from (0.0:inf);
    (* type = "instance", desc = "bottom metal index (1=M1 .. 4=M4)" *)
    parameter integer mmin     = 1    from [1:4];
    (* type = "instance", desc = "top metal index (1=M1 .. 4=M4)" *)
    parameter integer mmax     = 4    from [1:4];
    (* type = "instance", desc = "substrate-isolation block (layout/LVS only)" *)
    parameter integer subblock = 0    from [0:1];
    (* type = "instance", desc = "0: C only, 1: full equivalent circuit" *)
    parameter integer rfmodel  = 0    from [0:1];
    (* type = "instance", desc = "factor on the plate to substrate C" *)
    parameter real    subscale = 1.0  from [0.0:inf);
    (* type = "instance", desc = "corner factor on C" *)
    parameter real    cscale   = 1.0  from (0.0:inf);
    (* type = "instance", desc = "corner factor on metal R" *)
    parameter real    rscale   = 1.0  from (0.0:inf);
    (* type = "instance", desc = "mismatch deviate, in sigma" *)
    parameter real    mmz      = 0.0;

    // ---- model parameters ----------------------------------------------------
    (* units = "1/K", desc = "temperature coefficient of C" *)
    parameter real    tc1      = 30e-6;
    (* units = "1/K", desc = "temperature coefficient of metal R" *)
    parameter real    tcr      = 3.5e-3;
    (* desc = "dielectric loss tangent at fref" *)
    parameter real    tand     = 1.0e-3 from [0.0:inf);
    (* units = "Hz", desc = "frequency at which tand is exact" *)
    parameter real    fref     = 2.44e9 from (0.0:inf);
    (* units = "Ohm", desc = "series R of a substrate branch" *)
    parameter real    rsub     = 7.0e3  from (0.0:inf);
    (* units = "C", desc = "temperature of the coefficients" *)
    parameter real    tnom     = 27.0;

    // Device multiplicity goes through the Verilog-AMS standard $mfactor, read
    // in the analog block. The ADMS/Xyce toolchain has no $mfactor, so under
    // __XYCE__ expose an explicit `mult` instead, mirroring cap_cmomi.va and
    // r3_cmc.va. Neither wired build defines __XYCE__.
`ifdef __XYCE__
    (* type = "instance", desc = "number of devices in parallel" *)
    parameter real    mult     = 1.0  from (0.0:inf);
`endif

    // ---- named branches ------------------------------------------------------
    branch (PLUS, MINUS) br_leak;
    branch (na, nb)      br_cmain;
    branch (PLUS, na)    br_sp;
    branch (nb, MINUS)   br_sm;
    branch (PLUS, np)    br_cp;
    branch (MINUS, nm)   br_cm;
    branch (np, SUB)     br_rp;
    branch (nm, SUB)     br_rm;

    real lu, wu, dens, rim, le, we, cnom_fF, Cmain, dT, mMod;
    real frac, ncutr, nfx, nfy, wsp, t, Rmetal, Rside, Lside, kst, Cplate;
    integer Nlay, nv, nh;

    // Weak DC anchor across the plates. A pure ddt() contribution leaves the
    // node pair without a DC path, which is a singular operating point for an
    // otherwise unconnected instance. 1e-12 S is a 1 Tohm parallel leak.
    localparam real GLEAK = 1.0e-12;

    // Closed form for the series R: metal sheet R [Ohm/sq], via stack per cut
    // [Ohm] and the factor that makes it meet the EM anchor.
    localparam real RSHEET = 0.088;
    localparam real RCUT   = 9.0;
    localparam real KEM    = 1.2355;

    // Local mismatch [1 x sqrt(fF)]: sigma(C)/C = AMM / sqrt(C / fF).
    localparam real AMM    = 0.0085;

    analog begin

        // ---- device multiplicity --------------------------------------------
        // The simulator already scales the device stamp by m (ngspice/OSDI and
        // gnucap both do), so the model must NOT scale by mMod itself or the
        // result goes as m^2. It enters only the mismatch term, where m devices
        // in parallel average out.
`ifdef __XYCE__
        mMod = mult;
`else
        mMod = $mfactor;
`endif

        // ---- units: parameters arrive in SI, model math in micrometres ------
        lu = l * 1.0e6;
        wu = w * 1.0e6;
        Nlay = mmax - mmin + 1;
        if (Nlay < 1) Nlay = 1;
        dT = $temperature - (tnom + `P_CELSIUS0);

        // ---- density [fF/um^2] and dead rim [um] per stack ------------------
        rim = 0.20;
        case (10 * mmin + mmax)
            14:      begin dens = 1.107; rim = 0.207; end
            24:      begin dens = 0.852; rim = 0.193; end
            34:      begin dens = 0.504; rim = 0.121; end
            13:      dens = 0.76;
            23:      dens = 0.50;
            12:      dens = 0.50;
            11:      dens = 0.29;
            default: dens = 0.17;
        endcase
        le = lu - 2.0 * rim;
        we = wu - 2.0 * rim;
        if (le < 0.1) le = 0.1;
        if (we < 0.1) we = 0.1;

        cnom_fF = dens * le * we;
        Cmain   = cnom_fF * 1.0e-15 * cscale * (1.0 + tc1 * dT)
                  * (1.0 + mmz * AMM / sqrt(mMod * cnom_fF));

        // ---- contributions ---------------------------------------------------
        I(br_cmain) <+ Cmain * ddt(V(br_cmain));
        I(br_leak)  <+ GLEAK * V(br_leak);

        if (rfmodel == 1) begin
            // ---- series metal and via cuts, levels share the current --------
            // nh levels have fingers along Y off a spine along X, nv levels
            // the other way round. Terms: spine, Y fingers, X fingers, cuts.
            frac = 1.0 / Nlay;
            nv   = Nlay / 2;
            nh   = Nlay - nv;
            wsp  = 0.2 * nh + 0.385 * nv;
            nfx  = floor((lu - 0.5) / 0.82);
            nfy  = floor((wu - 0.5) / 0.82);
            ncutr = floor(wu / 0.47);
            if (nfx < 1.0)   nfx = 1.0;
            if (nfy < 1.0)   nfy = 1.0;
            if (ncutr < 1.0) ncutr = 1.0;
            t = (nh * frac) * (nh * frac) * RSHEET * max(lu - 0.51, 0.2) / wsp / 3.0
              + nh * frac * frac * RSHEET * max(wu - 0.415, 0.2) / 0.2 / 3.0 / nfx;
            if (nv > 0)
                t = t + nv * frac * frac * RSHEET * max(lu - 0.41, 0.2) / 0.2 / 3.0 / nfy;
            if (Nlay > 1)
                t = t + ((nh * frac) * (nh * frac) + frac * frac) * RCUT / ncutr;
            Rmetal = 2.0 * t * KEM * rscale * (1.0 + tcr * dT);

            // ---- series branch, half of R and L on each side ----------------
            Rside = 0.5 * (Rmetal + tand / (`M_TWO_PI * fref * Cmain));
            Lside = 0.2e-12 * lu;
            V(br_sp) <+ Rside * I(br_sp) + Lside * ddt(I(br_sp));
            V(br_sm) <+ Rside * I(br_sm) + Lside * ddt(I(br_sm));
            V(br_sp) <+ white_noise(4.0 * `P_K * $temperature * Rside, "rs");
            V(br_sm) <+ white_noise(4.0 * `P_K * $temperature * Rside, "rs");

            // ---- plate to substrate -----------------------------------------
            kst    = (mmin == 1) ? 1.0 : ((mmin == 2) ? 0.80 : 0.58);
            Cplate = kst * subscale * (0.00277 * lu * wu + 0.119 * (lu + wu)) * 1.0e-15;
            I(br_cp) <+ Cplate * ddt(V(br_cp));
            I(br_cm) <+ Cplate * ddt(V(br_cm));
            I(br_rp) <+ V(br_rp) / rsub;
            I(br_rm) <+ V(br_rm) / rsub;
        end else begin
            V(br_sp) <+ 0.0;
            V(br_sm) <+ 0.0;
            V(br_rp) <+ 0.0;
            V(br_rm) <+ 0.0;
        end

    end

endmodule
