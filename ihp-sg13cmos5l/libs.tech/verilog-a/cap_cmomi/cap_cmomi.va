// cap_cmomi - interdigitated metal-oxide-metal capacitor, Verilog-A compact model
//             (ihp-sg13cmos5l port: reduced Metal1..Metal4 thin-metal stack)
//
// Copyright 2026 IHP PDK Authors
//
// Licensed under the Apache License, Version 2.0 (the "License");
// you may not use this file except in compliance with the License.
// You may obtain a copy of the License at
//
//     https://www.apache.org/licenses/LICENSE-2.0
//
// Unless required by applicable law or agreed to in writing, software
// distributed under the License is distributed on an "AS IS" BASIS,
// WITHOUT WARRANTIES OR CONDITIONS OF ANY KIND, either express or implied.
// See the License for the specific language governing permissions and
// limitations under the License.
//
// =============================================================================
// ***  APPROXIMATE MODEL -- NOT YET VALIDATED ON ihp-sg13cmos5l SILICON  ***
//
//   Every coefficient in this model except the single-side feed term is
//   TRANSFERRED from the sg13g2 characterisation (IHP "MOM model development
//   notes v4", 2022), which was
//   fitted on the g2 thin-metal stack (Metal1..Metal5).  cmos5l uses only the
//   four thin metals Metal1..Metal4, so the model is re-used here BY LAYER
//   COUNT N = mmax - mmin + 1: an N-layer cmos5l device borrows the g2 N-layer
//   coefficients.  NONE of these numbers are measured on cmos5l silicon, and the
//   N = 2 set is additionally an extrapolation (see below).  Treat all results
//   as engineering estimates.  The single-side feed term is instead fitted to
//   this PCell's own drawn geometry with a field solve, because the structure the
//   notes characterised is not the one drawn here.  A proper re-fit is pending
//   cmos5l silicon
//   (matched-pair / array test structures, ~3-6 months); until then this is the
//   best-available nominal model and is intentionally shipped so designers can
//   simulate a physically-reasonable cap_cmomi today.
// =============================================================================
//
// Model source: IHP "MOM model development notes v4" (2022), an EM-fitted RF
//   equivalent circuit for the interdigitated MoM capacitor on the thin-metal
//   stack.  g2 characterised N = 3,4,5 (M1..M5 subsets).  This cmos5l port keeps
//   only N = 2,3,4 (Metal1..Metal4 subsets); the native g2 N = 5 (needs Metal5)
//   is dropped because cmos5l has no Metal5.
//
// Fit validity (from the notes, unchanged in substance; here g2-transferred):
//   the area/feed capacitance is the trustworthy quantity across the drawn size
//   range.  The RF branches are characterised within a limited window only.  The
//   series inductance is FEED-keyed: feed=double uses the two-sided (opposite-
//   end) loop fit (notes p21, ~20% at 50 GHz), feed=same/none use the single-
//   side local-L fit (p16 SRF).  For feed=same/none and small-to-mid feed=double
//   the L is a small correction (<~10% of |Z|) below 50 GHz.  For LARGE
//   feed=double the two-sided loop L is big enough to self-resonate IN-BAND
//   (l~60um ~30 GHz, ~30x30 ~45 GHz) against a two-sided SRF the notes never
//   publish -- treat the default-feed SRF near or above those frequencies as an
//   unvalidated prediction.  The substrate shunt (Cox, Rsub||Csub) is ~10% over
//   0..100 GHz (g2 fit); beyond that window the polynomials extrapolate (well
//   behaved but unvalidated); Rsub can go negative for very large devices and is
//   clamped to a floor.  Corner/mismatch spread is not modelled (returns
//   nominal); pending silicon.
//
// Interdigitated horizontal comb rows on every used metal, all layers
// via-stacked into solid walls, adjacent rows of opposite polarity.
//   length -> X (finger length), width -> Y (row count).
//
// Equivalent circuit (series arm PLUS..MINUS plus a substrate shunt to SUB):
//
//   PLUS --(Lskin || Rskin)-- Cmain --(Lcore)-- (Rseries)-- MINUS
//                                         |
//                                        Cox        (shunt on the MINUS-side node)
//                                         |
//                                    (Rsub || Csub)
//                                         |
//                                        SUB
//
// Low-frequency capacitance:
//   C_total = density[N] * active_area  +  Cfeed         [fF]
//     Cfeed = 0.1625 * pad_len + 0.0916      (feed == 'same')
//           = 0.152  * pad_len               (feed == 'double')
//           = 0                              (feed == 'none')
//     pad_len = active_y*0.89 + 0.42, the drawn height of the stacked pads [um]
//   density[N] is the ACTIVE-AREA density.  The opposite-side (double) feed adds
//   a real capacitance over the bare array, measured on the via-fixed cell as
//   Cfeed_dbl = C(feed='double') - C(feed='none') = 0.152*pad_len (through
//   origin, four widths at Metal1..Metal4, worst residual 0.03 fF).  The notes
//   dropped it to zero ("assume zero", p7-8), which left small feed=double
//   devices reading low by construction; the via fix also removed a density
//   deficit that had partly masked it, so the residual now stands on its own and
//   is billed.  Dropping it made the default feed=double device (w=l=5 um) read
//   about 3.6% low, size-dependent: ~10% at w=l=2 um down to ~0.1% at 100 um.
//
//   ROW COUNT.  active_y counts the coupled rows this PCell DRAWS, floor(w/0.89).
//   The notes subtract one because their characterised structure ends in single
//   fingers that have no counter electrode (p3) and one pitch of its width
//   therefore does not couple; the drawn cell here has no such fingers.  The
//   subtraction was a property of that structure's boundary, not of the device,
//   and carrying it over under-counted every device by one row: about 1% at
//   w = 80 um and a factor of two at w = 2 um.  The construction is inherited
//   from the reference generator, so the sg13g2 twin has the same mismatch.
//   density[N] itself is unchanged: the notes define it per coupled unit cell,
//   which transfers directly.  It remains the g2-transferred value pending the
//   cmos5l silicon campaign, which measures exactly this scalar per N.
//
//   INVARIANT UNDER A CAPACITANCE CORRECTION.  For feed=same/none the series
//   inductance is derived as Lcore = 1/(w_SRF^2 * Cmain) from the notes' p16 SRF
//   fits, so correcting Cmain moves L and leaves the resonance where it was
//   characterised.  SRF is the preserved quantity, L is not.  For feed=double
//   Lcore is a direct loop fit (p21) that does not involve Cmain and does not
//   move at all.
//
// COEFFICIENT PROVENANCE / LAYER-COUNT KEYING (cmos5l = M1..M4)
//   Every coefficient is selected by the metal LAYER COUNT  N = mmax - mmin + 1
//   (and, for the oxide shunt, by the bottom-metal identity mmin).  Sourced
//   values by N (all g2-characterised, TRANSFERRED to cmos5l here):
//       N = 3 , N = 4  -> g2-measured (borrowed by layer count)
//       N = 2          -> extrapolated (density 0.55, OUR number) -- e.g. an
//                         M3..M4 or M1..M2 two-metal cmos5l subset
//   The single-side feed term is the exception to all of this: it is measured on
//   the cell as drawn (see the Cfeed block below) and carries no layer keying,
//   because the two plates sit on the top two metals whatever N is.
//   On cmos5l NONE of these are silicon-measured (see the top-of-file banner).
//   The oxide Cox is keyed by the BOTTOM metal (mmin): mmin==1 (M1 bottom) is the
//   largest bottom-to-substrate coupling and reuses the notes' 5-layer Cox set;
//   mmin==2 the 4-layer set; mmin>=3 the 3-layer set.  Keying by mmin (not by
//   layer count) is our physically-motivated inference and is correct for a
//   reduced-top stack (the bottom-metal distance sets Cox regardless of the top
//   metal), which is exactly the cmos5l M1..M4 case.
//
// Terminals:
//   PLUS   - plate 1
//   MINUS  - plate 2
//   SUB    - substrate / bulk reference for the oxide shunt (tie to gnd for the
//            classic 2-terminal behaviour; the ngspice wrapper subckt does this)
//
// Instance parameters (per-device geometry / configuration):
//   w        - capacitor width  [m]  (default 5 um)   MAPS TO Y (row stacking)
//   l        - capacitor length [m]  (default 5 um)   MAPS TO X (finger length)
//   mmin     - bottom metal index (1 = M1 .. 4 = M4)  (default 1)
//   mmax     - top metal index    (1 = M1 .. 4 = M4)  (default 4, full stack)
//   feed     - feed style code: 0 = none, 1 = same, 2 = double (default 2)
//   subblock - 0|1 substrate-isolation block (layout/LVS only, no electrical
//              effect available; accepted for interface parity)
// -----------------------------------------------------------------------------

`include "disciplines.vams"
`include "constants.vams"

module cap_cmomi(PLUS, MINUS, SUB);

    inout PLUS, MINUS, SUB;
    electrical PLUS, MINUS, SUB;
    electrical nsk, ncap, nl, nox;   // internal series/shunt nodes

    // ---- instance parameters -------------------------------------------------
    (* type = "instance", desc = "width (Y, row stacking)",  units = "m" *)
    parameter real    w        = 5e-6 from (0.0:inf);
    (* type = "instance", desc = "length (X, finger length)", units = "m" *)
    parameter real    l        = 5e-6 from (0.0:inf);
    (* type = "instance", desc = "bottom metal index (1=M1 .. 4=M4)" *)
    parameter integer mmin     = 1    from [1:4];
    (* type = "instance", desc = "top metal index (1=M1 .. 4=M4)" *)
    parameter integer mmax     = 4    from [1:4];
    (* type = "instance", desc = "feed code: 0=none 1=same 2=double" *)
    parameter integer feed     = 2    from [0:2];
    (* type = "instance", desc = "substrate-isolation block (layout/LVS only)" *)
    parameter integer subblock = 0    from [0:1];

    // Device multiplicity is handled through the Verilog-AMS standard $mfactor
    // (read in the analog block).  The ADMS/Xyce toolchain has no $mfactor, so
    // under __XYCE__ expose an explicit `mult` instance parameter as the
    // fallback, mirroring r3_cmc.va.  Neither wired build (openvaf/OSDI, gnucap-mg)
    // defines __XYCE__, so both take the $mfactor path.
`ifdef __XYCE__
    (* type = "instance", desc = "number of devices in parallel" *)
    parameter real    mult     = 1.0  from (0.0:inf);
`endif

    // ---- named branches ------------------------------------------------------
    branch (PLUS , nsk )  br_lskin, br_rskin;   // skin: L || R
    branch (nsk  , ncap)  br_cmain;             // main capacitance
    branch (ncap , nl  )  br_lcore;             // core series inductance
    branch (nl   , MINUS) br_rser;              // series resistance
    branch (nl   , nox )  br_cox;               // oxide coupling
    branch (nox  , SUB )  br_rsub, br_csub;     // substrate: R || C
    branch (PLUS , SUB )  br_lkp;               // weak DC anchor
    branch (MINUS, SUB )  br_lkm;               // weak DC anchor

    real lu, wu, lw, ratio;
    integer Nc, Nlay;
    real ax, ay, active_x, active_y, active_area, pad_len;
    real issame, isdbl, density, cfeed_fF, cmain_fF, Cmain;
    real Rseries, Lcore, Rskin1, Lskin_c, Lskin_s, Rskin, Lskin;
    real cox0, cox1, cox2, Cox, Rsub, Csub, srf_ss, wsrf;
    real mMod;   // device multiplicity ($mfactor)

    // weak anchor conductance for otherwise-floating internal islands [S]
    localparam real GLEAK = 1.0e-12;

    // Feed capacitance coefficients.  These three are the only C coefficients in
    // this file that cannot be looked up in the reference notes: they are fitted
    // here, on the cell as drawn.  The same names carry the same values in the
    // PCell (cap_cmomi_code.py) and the xschem symbol; the block below explains
    // where they come from.  Single-side feed (feed=='same'):
    //   Cfeed = CFEED_SLOPE*pad_len + CFEED_END.  Opposite-side (feed=='double'):
    //   Cfeed = CFEED2_SLOPE*pad_len (through origin).
    localparam real CFEED_SLOPE  = 0.1625;  // [fF/um] single-side, against drawn pad height
    localparam real CFEED_END    = 0.0916;  // [fF]    single-side end fringing at pad_len -> 0
    localparam real CFEED2_SLOPE = 0.152;   // [fF/um] opposite-side (double) feed vs bare array

    analog begin

        // ---- device multiplicity (Verilog-AMS standard $mfactor) ------------
        //   r3_cmc.va idiom (see r3_cmc.va): read $mfactor into mMod, with an
        //   explicit `mult` parameter for the ADMS/Xyce path that lacks $mfactor.
        //   The plain parallel-multiplicity scaling (C*m, R/m, L/m) is applied by
        //   the simulator automatically -- ngspice/OSDI and gnucap both multiply
        //   the device stamps by m -- so the model must NOT scale the elements by
        //   mMod itself (doing so double-counts and yields m^2).  mMod is read
        //   here as the standard-compliant multiplicity handle and is reserved for
        //   the future mismatch/statistical model, where the local spread narrows
        //   as 1/sqrt(mMod*area) exactly as r3_cmc does it.
`ifdef __XYCE__
        mMod = mult;
`else
        mMod = $mfactor;
`endif

        // ---- units: params arrive in SI, model math in micrometres ----------
        lu = l * 1.0e6;
        wu = w * 1.0e6;
        lw = wu + lu;
        ratio = lu / wu;

        // ---- layer count (clamped >= 1) -------------------------------------
        Nc   = mmax - mmin + 1;
        Nlay = (Nc < 1) ? 1 : Nc;

        // ---- unit-cell tiling (unit cell 0.84 x 0.89 um) --------------------
        //   active_x = floor(l/0.84) ; active_y = floor(w/0.89)
        // The notes take the active area to be the unit cells that HAVE a
        // counter electrode (p3: "the outer rows with single fingers are not
        // included here").  Their characterised structure ends in fingers with
        // nothing facing them, so one pitch of its width does not couple, and
        // subtracting a row was right FOR THAT STRUCTURE.  The PCell terminates
        // the array at the last coupled row instead and draws no unpaired
        // fingers, so at a given w it fits floor(w/0.89) coupled rows and the
        // subtraction no longer describes it.  Counting the drawn bars settles
        // this without a field solver; see cap_cmomi_geometry_test.py, which
        // compares the drawn rows against the row count this model bills.
        //
        // A drawn dimension that is an exact multiple of the pitch (e.g. l=21um
        // =25*0.84) round-trips through *1e6 to one ULP below the integer, and
        // floor() then lands on k or k-1 depending on the toolchain's division
        // vs reciprocal-multiply codegen.  This must agree with the PCell layout
        // and the C-label for every drawn geometry, so snap to the pitch grid
        // with a sub-grid epsilon (1e-6 cell = 0.84 pm << layout grid) before the
        // floor: an exact k-pitch resolves to k on ANY toolchain, a genuine
        // (k-eps) still floors to k-1.  Apply the SAME rule in the PCell/subckt.
        //
        // The floors clamp the way the PCell's do.  Note the two clamps differ:
        // a row needs a facing row, so the layout never draws fewer than TWO,
        // while one column of fingers is a valid (if pointless) cell.  Below
        // w = 1.78 um that clamp is the only thing setting the row count, and
        // the PCell's minimum w is 2 um, so nothing reachable from a layout
        // lands there; a hand-written netlist can, and used to get a device one
        // row and one pitch of pad smaller than the one that would be drawn.
        ax = floor(lu / 0.84 + 1.0e-6);
        ay = floor(wu / 0.89 + 1.0e-6);
        active_x = (ax < 1.0) ? 1.0 : ax;
        active_y = (ay < 2.0) ? 2.0 : ay;
        active_area = active_x * active_y * 0.84 * 0.89;
        // The drawn stacked feed pads span the whole array plus half a bar at
        // each end, which is exactly active_y*0.89 + 2*0.21 um of the PCell's
        // own painting.  See the Cfeed note below for why this replaced the
        // notes' feed_width.
        pad_len = active_y * 0.89 + 0.42;

        issame = (feed == 1) ? 1.0 : 0.0;
        isdbl  = (feed == 2) ? 1.0 : 0.0;

        // ---- area capacitance density [fF/um^2] by layer count N ------------
        //   N<=2 -> 0.55 (extrapolated, cmos5l 2-metal subset)
        //   N=3 -> 0.82 ; N>=4 -> 1.09   (g2-measured, transferred by count)
        density = (Nlay <= 2) ? 0.55 :
                  (Nlay == 3) ? 0.82 : 1.09;

        // ---- single-side feed capacitance [fF] ------------------------------
        //   MEASURED ON THE DRAWN CELL, not transferred.  The notes give
        //   cfeed_per_um = {2:0.70, 3:0.97, 4:1.28} fF/um against feed_width, for
        //   a feed section built as an extended fan-in with a via column tying
        //   every polarity tower across all metals.  This PCell does not draw
        //   that.  It draws two plates 0.90 um wide on the top metal and the one
        //   below it, overlapping completely with no via between them, and a
        //   plate overlap at the 0.54 um inter-metal spacing cannot reach
        //   1.28 fF per um of feed width without a pad about 19 um wide.  The
        //   reference generator does not reproduce the published number either,
        //   so this is not a porting regression; neither generator draws what was
        //   characterised, and the notes do not contain enough of that structure
        //   to rebuild it.
        //
        //   So the term below is fitted to the cell as drawn, from an
        //   electrostatic field solve of the PCell's own three feed branches in
        //   one shared domain: Cfeed = C(feed='same') - C(feed='none').  Four
        //   widths at Metal1..Metal4 give 0.1625*pad_len + 0.0916 fF, worst
        //   residual 3 aF, which is at the measurement floor and is not a
        //   statement of the term's accuracy.  The regressor is pad_len rather
        //   than the notes' feed_width on geometric grounds, not statistical
        //   ones: over the calibrated range the two differ by a constant, so
        //   they fit equally well, and pad_len is what the PCell paints.
        //
        //   Three further layer windows at w=7 give 1.126 (N=2), 1.160 and 1.165
        //   (N=3) and 1.171 (N=4) fF.  Flat for N>=3; the N=2 window sits about
        //   3% lower, which is inside this term's own error bar, so there is no
        //   per-N table here any more.  The residual trend is unmodelled and
        //   bills an M3..M4 device's feed about 4% (50 aF) high, some 0.3% of
        //   such a part.  Run-to-run scatter of the solver, from eight repeats
        //   of identical inputs, is about 2.5 aF per solve: ~0.3% of the term
        //   at w=7 and ~0.8% at w=2 after differencing, with boundary placement
        //   worth about as much again.  Evidence and the solver configurations
        //   are archived with the project.
        //
        //   SCALE.  This term was first calibrated on a field solve of the
        //   sparse-via cell, whose active area then read well below the
        //   transferred density[N].  The via fix (tooth-tip vias) closed that
        //   gap: on the via-fixed cell the solved active-area density agrees with
        //   density[N] to about 1%, so the single-side term needs no rescaling.
        //   If a silicon campaign moves density[N], read this coefficient as
        //   moving by the same factor.
        //
        //   The opposite-side (double) feed is now billed at CFEED2_SLOPE*pad_len
        //   (see the header).  The same field solve on the via-fixed cell puts it
        //   at 0.73 fF at w=5 rising to 2.26 fF at w=15, growing linearly with
        //   pad_len through the origin.  With it billed, the step the model
        //   predicts when a designer switches from 'double' to 'same' matches the
        //   drawn step (the two feed terms differ only by the single-side end
        //   fringing CFEED_END).

        // ---- main capacitance [F] -------------------------------------------
        cfeed_fF = issame * (CFEED_SLOPE * pad_len + CFEED_END)   // single-side
                 + isdbl  * (CFEED2_SLOPE * pad_len);             // opposite-side (double)
        cmain_fF = density * active_area + cfeed_fF;
        Cmain    = cmain_fF * 1.0e-15;

        // ---- series resistance [Ohm], l,w in um -----------------------------
        //   'same'  : layer-independent ; else per-N (opposite-side / no-feed).
        //   'none' reuses the opposite-side (double) R set: a bare no-feed array
        //   is both-ends-accessible, so its low R (~65% of the same-side R) is the
        //   double signature; paired with the single-side (local) Lcore below it
        //   is a coherent no-feed device, not a topology mismatch.
        if (issame > 0.5)
            Rseries = 0.22 + 0.40 * ratio;
        else
            Rseries = (Nlay <= 3) ? 0.10 + 0.31 * ratio :
                                    0.14 + 0.27 * ratio;
        if (Rseries < 1.0e-3) Rseries = 1.0e-3;

        // ---- core series inductance [H] -- keyed by FEED --------------------
        //   The p18 fit is the OPPOSITE-END (two-sided) loop inductance: the
        //   current runs the full finger length down one comb and back the
        //   other, a long loop worth tens of pH.  It is the right quantity ONLY
        //   for feed=double (PLUS/MINUS at opposite ends).  A same-side
        //   (feed=same) or bare (feed=none) device has no such loop; its series
        //   inductance is the small LOCAL value the notes measure single-side
        //   (p13-16, ~0.2..1.3 pH).  The notes give single-side L only via the p16
        //   SRF fit (width-independent, length-driven), so recover it self-
        //   consistently from the model's own Cmain:
        //       L_ss = 1 / ( (2*pi*SRF_ss)^2 * Cmain )
        //   SRF_ss [Hz] from the p16 1/SRF-vs-length lines (l in um):
        //       N<=3 : 1e9/(7.68e-5 + 6.64e-5*l)
        //       N>=4 : 1e9/(8.82e-4 + 4.72e-5*l)
        //   Using the loop fit for feed=same overstates L 15..90x and flips the
        //   in-band series reactance inductive on large devices (e.g. 60x10
        //   same-feed goes inductive above ~30 GHz); feed keying removes that.
        //   feed code: 2=double (loop) ; 1=same, 0=none (both -> single-side).
        if (feed == 2) begin
            Lcore = (4.886 + 3.117 * ratio + 0.510 * lu - 2.526 * sqrt(lu)) * 1.0e-12;
        end else begin
            srf_ss = (Nlay <= 3) ? 1.0e9 / (7.68e-5 + 6.64e-5 * lu) :
                                   1.0e9 / (8.82e-4 + 4.72e-5 * lu);
            wsrf  = `M_TWO_PI * srf_ss;
            Lcore = 1.0 / (wsrf * wsrf * Cmain);
        end
        if (Lcore < 1.0e-18) Lcore = 1.0e-18;

        // ---- skin effect (PDF p12, refinement) ------------------------------
        //   Rskin = Rskin1*l [Ohm] ; Lskin = (Lskin_c + Lskin_s*l) [pH]
        Rskin1  = (Nlay <= 3) ? 0.031   : 0.035;
        Lskin_c = (Nlay <= 3) ? 0.214   : 0.010;
        Lskin_s = (Nlay <= 3) ? 0.02256 : 0.0626;
        Rskin   = Rskin1 * lu;
        if (Rskin < 1.0e-3) Rskin = 1.0e-3;
        Lskin   = (Lskin_c + Lskin_s * lu) * 1.0e-12;

        // ---- substrate shunt: Cox in series with (Rsub || Csub) -------------
        //   Cox is the oxide capacitance from the BOTTOM MoM plate to the
        //   substrate, so it scales with the bottom-metal distance.  The source
        //   notes (p22) index the three Cox sets by LAYER COUNT 3/4/5 (verbatim
        //   "For 3/4/5 MOM layers").  We RE-KEY them by the bottom metal index
        //   (mmin) -- our physically-motivated inference: the notes' sweep kept
        //   the top at M5, so "5 layers"=="M1 bottom", "4"=="M2", "3"=="M3".  On
        //   the cmos5l reduced-top (M1..M4) stack the top metal is M4, but Cox is
        //   set by the BOTTOM metal distance, so the mmin keying is the correct
        //   transfer here:
        //     mmin==1 (M1 bottom) : 5-layer (largest) Cox set
        //     mmin==2 (M2 bottom) : 4-layer set
        //     mmin>=3 (M3 bottom) : 3-layer set
        if (mmin == 1) begin
            cox0 = 1.725;   cox1 = 0.1192;  cox2 = 0.019406;
        end else if (mmin == 2) begin
            cox0 = 1.240;   cox1 = 0.1139;  cox2 = 0.011417;
        end else begin
            cox0 = 1.052;   cox1 = 0.09867; cox2 = 0.011364;
        end
        Cox = (cox0 + cox1 * lw + cox2 * wu * lu) * 1.0e-15;

        //   Rsub / Csub coefficients common to all N
        Rsub = 3144.0 - 9.6942 * lw + 0.0207848 * wu * lu;
        if (Rsub < 1.0e-2) Rsub = 1.0e-2;
        Csub = (9.8833 + 0.089195 * lw + 0.000675931 * wu * lu) * 1.0e-15;

        // ---- constitutive relations -----------------------------------------
        // skin arm: inductor (voltage-defined) parallel resistor (current-defined)
        V(br_lskin) <+ Lskin   * ddt(I(br_lskin));
        I(br_rskin) <+ V(br_rskin) / Rskin;
        // main cap, core inductor, series resistor
        I(br_cmain) <+ Cmain   * ddt(V(br_cmain));
        V(br_lcore) <+ Lcore   * ddt(I(br_lcore));
        I(br_rser)  <+ V(br_rser)  / Rseries;
        // substrate shunt: Cox in series with Rsub || Csub
        I(br_cox)   <+ Cox     * ddt(V(br_cox));
        I(br_rsub)  <+ V(br_rsub)  / Rsub;
        I(br_csub)  <+ Csub    * ddt(V(br_csub));
        // weak DC anchors so floating ports/islands never give a singular matrix
        I(br_lkp)   <+ GLEAK * V(br_lkp);
        I(br_lkm)   <+ GLEAK * V(br_lkm);

    end
endmodule
