************************************************************************
*
* Copyright 2024 IHP PDK Authors
*
* Licensed under the Apache License, Version 2.0 (the "License");
* you may not use this file except in compliance with the License.
* You may obtain a copy of the License at
*
*    https://www.apache.org/licenses/LICENSE-2.0
*
* Unless required by applicable law or agreed to in writing, software
* distributed under the License is distributed on an "AS IS" BASIS,
* WITHOUT WARRANTIES OR CONDITIONS OF ANY KIND, either express or implied.
* See the License for the specific language governing permissions and
* limitations under the License.
*
************************************************************************

* Library name: sg13g2_io
* Cell name: sg13g2_DCNDiode
* View name: schematic
.subckt sg13g2_DCNDiode anode cathode guard
XD1 sub! cathode dantenna l=27.78u w=1.26u m=1
XD0 sub! cathode dantenna l=27.78u w=1.26u m=1
XR0 anode sub! ptap1 R=5.191
.ends
* End of subcircuit definition.

* Library name: sg13g2_io
* Cell name: sg13g2_DCPDiode
* View name: schematic
.subckt sg13g2_DCPDiode anode cathode guard
XD1 anode cathode dpantenna l=27.78u w=1.26u m=1
XD0 anode cathode dpantenna l=27.78u w=1.26u m=1
XR0 guard sub! ptap1 R=17.289
.ends
* End of subcircuit definition.

* Library name: sg13g2_io
* Cell name: sg13g2_IOPadIOVss
* View name: schematic
.subckt sg13g2_IOPadIOVss vdd vss iovdd iovss
XI3 iovss iovss iovdd sg13g2_DCNDiode
XI2 iovss iovdd iovss sg13g2_DCPDiode
XR1 vss sub! ptap1 R=22.472
XR0 iovss sub! ptap1 R=169.45m
.ends
* End of subcircuit definition.

* Library name: sg13g2_io
* Cell name: sg13g2_Clamp_N43N43D4R
* View name: schematic
.subckt sg13g2_Clamp_N43N43D4R gate iovss pad
XN0[1] pad gate iovss sub! sg13_hv_nmos w=4.4u l=600.0n ng=1 ad=1.496e-12 as=1.496e-12 pd=9.48e-06 ps=9.48e-06 m=1
XN0[2] pad gate iovss sub! sg13_hv_nmos w=4.4u l=600.0n ng=1 ad=1.496e-12 as=1.496e-12 pd=9.48e-06 ps=9.48e-06 m=1
XN0[3] pad gate iovss sub! sg13_hv_nmos w=4.4u l=600.0n ng=1 ad=1.496e-12 as=1.496e-12 pd=9.48e-06 ps=9.48e-06 m=1
XN0[4] pad gate iovss sub! sg13_hv_nmos w=4.4u l=600.0n ng=1 ad=1.496e-12 as=1.496e-12 pd=9.48e-06 ps=9.48e-06 m=1
XN0[5] pad gate iovss sub! sg13_hv_nmos w=4.4u l=600.0n ng=1 ad=1.496e-12 as=1.496e-12 pd=9.48e-06 ps=9.48e-06 m=1
XN0[6] pad gate iovss sub! sg13_hv_nmos w=4.4u l=600.0n ng=1 ad=1.496e-12 as=1.496e-12 pd=9.48e-06 ps=9.48e-06 m=1
XN0[7] pad gate iovss sub! sg13_hv_nmos w=4.4u l=600.0n ng=1 ad=1.496e-12 as=1.496e-12 pd=9.48e-06 ps=9.48e-06 m=1
XN0[8] pad gate iovss sub! sg13_hv_nmos w=4.4u l=600.0n ng=1 ad=1.496e-12 as=1.496e-12 pd=9.48e-06 ps=9.48e-06 m=1
XN0[9] pad gate iovss sub! sg13_hv_nmos w=4.4u l=600.0n ng=1 ad=1.496e-12 as=1.496e-12 pd=9.48e-06 ps=9.48e-06 m=1
XN0[10] pad gate iovss sub! sg13_hv_nmos w=4.4u l=600.0n ng=1 ad=1.496e-12 as=1.496e-12 pd=9.48e-06 ps=9.48e-06 m=1
XN0[11] pad gate iovss sub! sg13_hv_nmos w=4.4u l=600.0n ng=1 ad=1.496e-12 as=1.496e-12 pd=9.48e-06 ps=9.48e-06 m=1
XN0[12] pad gate iovss sub! sg13_hv_nmos w=4.4u l=600.0n ng=1 ad=1.496e-12 as=1.496e-12 pd=9.48e-06 ps=9.48e-06 m=1
XN0[13] pad gate iovss sub! sg13_hv_nmos w=4.4u l=600.0n ng=1 ad=1.496e-12 as=1.496e-12 pd=9.48e-06 ps=9.48e-06 m=1
XN0[14] pad gate iovss sub! sg13_hv_nmos w=4.4u l=600.0n ng=1 ad=1.496e-12 as=1.496e-12 pd=9.48e-06 ps=9.48e-06 m=1
XN0[15] pad gate iovss sub! sg13_hv_nmos w=4.4u l=600.0n ng=1 ad=1.496e-12 as=1.496e-12 pd=9.48e-06 ps=9.48e-06 m=1
XN0[16] pad gate iovss sub! sg13_hv_nmos w=4.4u l=600.0n ng=1 ad=1.496e-12 as=1.496e-12 pd=9.48e-06 ps=9.48e-06 m=1
XN0[17] pad gate iovss sub! sg13_hv_nmos w=4.4u l=600.0n ng=1 ad=1.496e-12 as=1.496e-12 pd=9.48e-06 ps=9.48e-06 m=1
XN0[18] pad gate iovss sub! sg13_hv_nmos w=4.4u l=600.0n ng=1 ad=1.496e-12 as=1.496e-12 pd=9.48e-06 ps=9.48e-06 m=1
XN0[19] pad gate iovss sub! sg13_hv_nmos w=4.4u l=600.0n ng=1 ad=1.496e-12 as=1.496e-12 pd=9.48e-06 ps=9.48e-06 m=1
XN0[20] pad gate iovss sub! sg13_hv_nmos w=4.4u l=600.0n ng=1 ad=1.496e-12 as=1.496e-12 pd=9.48e-06 ps=9.48e-06 m=1
XN0[21] pad gate iovss sub! sg13_hv_nmos w=4.4u l=600.0n ng=1 ad=1.496e-12 as=1.496e-12 pd=9.48e-06 ps=9.48e-06 m=1
XN0[22] pad gate iovss sub! sg13_hv_nmos w=4.4u l=600.0n ng=1 ad=1.496e-12 as=1.496e-12 pd=9.48e-06 ps=9.48e-06 m=1
XN0[23] pad gate iovss sub! sg13_hv_nmos w=4.4u l=600.0n ng=1 ad=1.496e-12 as=1.496e-12 pd=9.48e-06 ps=9.48e-06 m=1
XN0[24] pad gate iovss sub! sg13_hv_nmos w=4.4u l=600.0n ng=1 ad=1.496e-12 as=1.496e-12 pd=9.48e-06 ps=9.48e-06 m=1
XN0[25] pad gate iovss sub! sg13_hv_nmos w=4.4u l=600.0n ng=1 ad=1.496e-12 as=1.496e-12 pd=9.48e-06 ps=9.48e-06 m=1
XN0[26] pad gate iovss sub! sg13_hv_nmos w=4.4u l=600.0n ng=1 ad=1.496e-12 as=1.496e-12 pd=9.48e-06 ps=9.48e-06 m=1
XN0[27] pad gate iovss sub! sg13_hv_nmos w=4.4u l=600.0n ng=1 ad=1.496e-12 as=1.496e-12 pd=9.48e-06 ps=9.48e-06 m=1
XN0[28] pad gate iovss sub! sg13_hv_nmos w=4.4u l=600.0n ng=1 ad=1.496e-12 as=1.496e-12 pd=9.48e-06 ps=9.48e-06 m=1
XN0[29] pad gate iovss sub! sg13_hv_nmos w=4.4u l=600.0n ng=1 ad=1.496e-12 as=1.496e-12 pd=9.48e-06 ps=9.48e-06 m=1
XN0[30] pad gate iovss sub! sg13_hv_nmos w=4.4u l=600.0n ng=1 ad=1.496e-12 as=1.496e-12 pd=9.48e-06 ps=9.48e-06 m=1
XN0[31] pad gate iovss sub! sg13_hv_nmos w=4.4u l=600.0n ng=1 ad=1.496e-12 as=1.496e-12 pd=9.48e-06 ps=9.48e-06 m=1
XN0[32] pad gate iovss sub! sg13_hv_nmos w=4.4u l=600.0n ng=1 ad=1.496e-12 as=1.496e-12 pd=9.48e-06 ps=9.48e-06 m=1
XN0[33] pad gate iovss sub! sg13_hv_nmos w=4.4u l=600.0n ng=1 ad=1.496e-12 as=1.496e-12 pd=9.48e-06 ps=9.48e-06 m=1
XN0[34] pad gate iovss sub! sg13_hv_nmos w=4.4u l=600.0n ng=1 ad=1.496e-12 as=1.496e-12 pd=9.48e-06 ps=9.48e-06 m=1
XN0[35] pad gate iovss sub! sg13_hv_nmos w=4.4u l=600.0n ng=1 ad=1.496e-12 as=1.496e-12 pd=9.48e-06 ps=9.48e-06 m=1
XN0[36] pad gate iovss sub! sg13_hv_nmos w=4.4u l=600.0n ng=1 ad=1.496e-12 as=1.496e-12 pd=9.48e-06 ps=9.48e-06 m=1
XN0[37] pad gate iovss sub! sg13_hv_nmos w=4.4u l=600.0n ng=1 ad=1.496e-12 as=1.496e-12 pd=9.48e-06 ps=9.48e-06 m=1
XN0[38] pad gate iovss sub! sg13_hv_nmos w=4.4u l=600.0n ng=1 ad=1.496e-12 as=1.496e-12 pd=9.48e-06 ps=9.48e-06 m=1
XN0[39] pad gate iovss sub! sg13_hv_nmos w=4.4u l=600.0n ng=1 ad=1.496e-12 as=1.496e-12 pd=9.48e-06 ps=9.48e-06 m=1
XN0[40] pad gate iovss sub! sg13_hv_nmos w=4.4u l=600.0n ng=1 ad=1.496e-12 as=1.496e-12 pd=9.48e-06 ps=9.48e-06 m=1
XN0[41] pad gate iovss sub! sg13_hv_nmos w=4.4u l=600.0n ng=1 ad=1.496e-12 as=1.496e-12 pd=9.48e-06 ps=9.48e-06 m=1
XN0[42] pad gate iovss sub! sg13_hv_nmos w=4.4u l=600.0n ng=1 ad=1.496e-12 as=1.496e-12 pd=9.48e-06 ps=9.48e-06 m=1
XN0[43] pad gate iovss sub! sg13_hv_nmos w=4.4u l=600.0n ng=1 ad=1.496e-12 as=1.496e-12 pd=9.48e-06 ps=9.48e-06 m=1
XN0[44] pad gate iovss sub! sg13_hv_nmos w=4.4u l=600.0n ng=1 ad=1.496e-12 as=1.496e-12 pd=9.48e-06 ps=9.48e-06 m=1
XN0[45] pad gate iovss sub! sg13_hv_nmos w=4.4u l=600.0n ng=1 ad=1.496e-12 as=1.496e-12 pd=9.48e-06 ps=9.48e-06 m=1
XN0[46] pad gate iovss sub! sg13_hv_nmos w=4.4u l=600.0n ng=1 ad=1.496e-12 as=1.496e-12 pd=9.48e-06 ps=9.48e-06 m=1
XN0[47] pad gate iovss sub! sg13_hv_nmos w=4.4u l=600.0n ng=1 ad=1.496e-12 as=1.496e-12 pd=9.48e-06 ps=9.48e-06 m=1
XN0[48] pad gate iovss sub! sg13_hv_nmos w=4.4u l=600.0n ng=1 ad=1.496e-12 as=1.496e-12 pd=9.48e-06 ps=9.48e-06 m=1
XN0[49] pad gate iovss sub! sg13_hv_nmos w=4.4u l=600.0n ng=1 ad=1.496e-12 as=1.496e-12 pd=9.48e-06 ps=9.48e-06 m=1
XN0[50] pad gate iovss sub! sg13_hv_nmos w=4.4u l=600.0n ng=1 ad=1.496e-12 as=1.496e-12 pd=9.48e-06 ps=9.48e-06 m=1
XN0[51] pad gate iovss sub! sg13_hv_nmos w=4.4u l=600.0n ng=1 ad=1.496e-12 as=1.496e-12 pd=9.48e-06 ps=9.48e-06 m=1
XN0[52] pad gate iovss sub! sg13_hv_nmos w=4.4u l=600.0n ng=1 ad=1.496e-12 as=1.496e-12 pd=9.48e-06 ps=9.48e-06 m=1
XN0[53] pad gate iovss sub! sg13_hv_nmos w=4.4u l=600.0n ng=1 ad=1.496e-12 as=1.496e-12 pd=9.48e-06 ps=9.48e-06 m=1
XN0[54] pad gate iovss sub! sg13_hv_nmos w=4.4u l=600.0n ng=1 ad=1.496e-12 as=1.496e-12 pd=9.48e-06 ps=9.48e-06 m=1
XN0[55] pad gate iovss sub! sg13_hv_nmos w=4.4u l=600.0n ng=1 ad=1.496e-12 as=1.496e-12 pd=9.48e-06 ps=9.48e-06 m=1
XN0[56] pad gate iovss sub! sg13_hv_nmos w=4.4u l=600.0n ng=1 ad=1.496e-12 as=1.496e-12 pd=9.48e-06 ps=9.48e-06 m=1
XN0[57] pad gate iovss sub! sg13_hv_nmos w=4.4u l=600.0n ng=1 ad=1.496e-12 as=1.496e-12 pd=9.48e-06 ps=9.48e-06 m=1
XN0[58] pad gate iovss sub! sg13_hv_nmos w=4.4u l=600.0n ng=1 ad=1.496e-12 as=1.496e-12 pd=9.48e-06 ps=9.48e-06 m=1
XN0[59] pad gate iovss sub! sg13_hv_nmos w=4.4u l=600.0n ng=1 ad=1.496e-12 as=1.496e-12 pd=9.48e-06 ps=9.48e-06 m=1
XN0[60] pad gate iovss sub! sg13_hv_nmos w=4.4u l=600.0n ng=1 ad=1.496e-12 as=1.496e-12 pd=9.48e-06 ps=9.48e-06 m=1
XN0[61] pad gate iovss sub! sg13_hv_nmos w=4.4u l=600.0n ng=1 ad=1.496e-12 as=1.496e-12 pd=9.48e-06 ps=9.48e-06 m=1
XN0[62] pad gate iovss sub! sg13_hv_nmos w=4.4u l=600.0n ng=1 ad=1.496e-12 as=1.496e-12 pd=9.48e-06 ps=9.48e-06 m=1
XN0[63] pad gate iovss sub! sg13_hv_nmos w=4.4u l=600.0n ng=1 ad=1.496e-12 as=1.496e-12 pd=9.48e-06 ps=9.48e-06 m=1
XN0[64] pad gate iovss sub! sg13_hv_nmos w=4.4u l=600.0n ng=1 ad=1.496e-12 as=1.496e-12 pd=9.48e-06 ps=9.48e-06 m=1
XN0[65] pad gate iovss sub! sg13_hv_nmos w=4.4u l=600.0n ng=1 ad=1.496e-12 as=1.496e-12 pd=9.48e-06 ps=9.48e-06 m=1
XN0[66] pad gate iovss sub! sg13_hv_nmos w=4.4u l=600.0n ng=1 ad=1.496e-12 as=1.496e-12 pd=9.48e-06 ps=9.48e-06 m=1
XN0[67] pad gate iovss sub! sg13_hv_nmos w=4.4u l=600.0n ng=1 ad=1.496e-12 as=1.496e-12 pd=9.48e-06 ps=9.48e-06 m=1
XN0[68] pad gate iovss sub! sg13_hv_nmos w=4.4u l=600.0n ng=1 ad=1.496e-12 as=1.496e-12 pd=9.48e-06 ps=9.48e-06 m=1
XN0[69] pad gate iovss sub! sg13_hv_nmos w=4.4u l=600.0n ng=1 ad=1.496e-12 as=1.496e-12 pd=9.48e-06 ps=9.48e-06 m=1
XN0[70] pad gate iovss sub! sg13_hv_nmos w=4.4u l=600.0n ng=1 ad=1.496e-12 as=1.496e-12 pd=9.48e-06 ps=9.48e-06 m=1
XN0[71] pad gate iovss sub! sg13_hv_nmos w=4.4u l=600.0n ng=1 ad=1.496e-12 as=1.496e-12 pd=9.48e-06 ps=9.48e-06 m=1
XN0[72] pad gate iovss sub! sg13_hv_nmos w=4.4u l=600.0n ng=1 ad=1.496e-12 as=1.496e-12 pd=9.48e-06 ps=9.48e-06 m=1
XN0[73] pad gate iovss sub! sg13_hv_nmos w=4.4u l=600.0n ng=1 ad=1.496e-12 as=1.496e-12 pd=9.48e-06 ps=9.48e-06 m=1
XN0[74] pad gate iovss sub! sg13_hv_nmos w=4.4u l=600.0n ng=1 ad=1.496e-12 as=1.496e-12 pd=9.48e-06 ps=9.48e-06 m=1
XN0[75] pad gate iovss sub! sg13_hv_nmos w=4.4u l=600.0n ng=1 ad=1.496e-12 as=1.496e-12 pd=9.48e-06 ps=9.48e-06 m=1
XN0[76] pad gate iovss sub! sg13_hv_nmos w=4.4u l=600.0n ng=1 ad=1.496e-12 as=1.496e-12 pd=9.48e-06 ps=9.48e-06 m=1
XN0[77] pad gate iovss sub! sg13_hv_nmos w=4.4u l=600.0n ng=1 ad=1.496e-12 as=1.496e-12 pd=9.48e-06 ps=9.48e-06 m=1
XN0[78] pad gate iovss sub! sg13_hv_nmos w=4.4u l=600.0n ng=1 ad=1.496e-12 as=1.496e-12 pd=9.48e-06 ps=9.48e-06 m=1
XN0[79] pad gate iovss sub! sg13_hv_nmos w=4.4u l=600.0n ng=1 ad=1.496e-12 as=1.496e-12 pd=9.48e-06 ps=9.48e-06 m=1
XN0[80] pad gate iovss sub! sg13_hv_nmos w=4.4u l=600.0n ng=1 ad=1.496e-12 as=1.496e-12 pd=9.48e-06 ps=9.48e-06 m=1
XN0[81] pad gate iovss sub! sg13_hv_nmos w=4.4u l=600.0n ng=1 ad=1.496e-12 as=1.496e-12 pd=9.48e-06 ps=9.48e-06 m=1
XN0[82] pad gate iovss sub! sg13_hv_nmos w=4.4u l=600.0n ng=1 ad=1.496e-12 as=1.496e-12 pd=9.48e-06 ps=9.48e-06 m=1
XN0[83] pad gate iovss sub! sg13_hv_nmos w=4.4u l=600.0n ng=1 ad=1.496e-12 as=1.496e-12 pd=9.48e-06 ps=9.48e-06 m=1
XN0[84] pad gate iovss sub! sg13_hv_nmos w=4.4u l=600.0n ng=1 ad=1.496e-12 as=1.496e-12 pd=9.48e-06 ps=9.48e-06 m=1
XN0[85] pad gate iovss sub! sg13_hv_nmos w=4.4u l=600.0n ng=1 ad=1.496e-12 as=1.496e-12 pd=9.48e-06 ps=9.48e-06 m=1
XN0[86] pad gate iovss sub! sg13_hv_nmos w=4.4u l=600.0n ng=1 ad=1.496e-12 as=1.496e-12 pd=9.48e-06 ps=9.48e-06 m=1
XN0[87] pad gate iovss sub! sg13_hv_nmos w=4.4u l=600.0n ng=1 ad=1.496e-12 as=1.496e-12 pd=9.48e-06 ps=9.48e-06 m=1
XN0[88] pad gate iovss sub! sg13_hv_nmos w=4.4u l=600.0n ng=1 ad=1.496e-12 as=1.496e-12 pd=9.48e-06 ps=9.48e-06 m=1
XN0[89] pad gate iovss sub! sg13_hv_nmos w=4.4u l=600.0n ng=1 ad=1.496e-12 as=1.496e-12 pd=9.48e-06 ps=9.48e-06 m=1
XN0[90] pad gate iovss sub! sg13_hv_nmos w=4.4u l=600.0n ng=1 ad=1.496e-12 as=1.496e-12 pd=9.48e-06 ps=9.48e-06 m=1
XN0[91] pad gate iovss sub! sg13_hv_nmos w=4.4u l=600.0n ng=1 ad=1.496e-12 as=1.496e-12 pd=9.48e-06 ps=9.48e-06 m=1
XN0[92] pad gate iovss sub! sg13_hv_nmos w=4.4u l=600.0n ng=1 ad=1.496e-12 as=1.496e-12 pd=9.48e-06 ps=9.48e-06 m=1
XN0[93] pad gate iovss sub! sg13_hv_nmos w=4.4u l=600.0n ng=1 ad=1.496e-12 as=1.496e-12 pd=9.48e-06 ps=9.48e-06 m=1
XN0[94] pad gate iovss sub! sg13_hv_nmos w=4.4u l=600.0n ng=1 ad=1.496e-12 as=1.496e-12 pd=9.48e-06 ps=9.48e-06 m=1
XN0[95] pad gate iovss sub! sg13_hv_nmos w=4.4u l=600.0n ng=1 ad=1.496e-12 as=1.496e-12 pd=9.48e-06 ps=9.48e-06 m=1
XN0[96] pad gate iovss sub! sg13_hv_nmos w=4.4u l=600.0n ng=1 ad=1.496e-12 as=1.496e-12 pd=9.48e-06 ps=9.48e-06 m=1
XN0[97] pad gate iovss sub! sg13_hv_nmos w=4.4u l=600.0n ng=1 ad=1.496e-12 as=1.496e-12 pd=9.48e-06 ps=9.48e-06 m=1
XN0[98] pad gate iovss sub! sg13_hv_nmos w=4.4u l=600.0n ng=1 ad=1.496e-12 as=1.496e-12 pd=9.48e-06 ps=9.48e-06 m=1
XN0[99] pad gate iovss sub! sg13_hv_nmos w=4.4u l=600.0n ng=1 ad=1.496e-12 as=1.496e-12 pd=9.48e-06 ps=9.48e-06 m=1
XN0[100] pad gate iovss sub! sg13_hv_nmos w=4.4u l=600.0n ng=1 ad=1.496e-12 as=1.496e-12 pd=9.48e-06 ps=9.48e-06 m=1
XN0[101] pad gate iovss sub! sg13_hv_nmos w=4.4u l=600.0n ng=1 ad=1.496e-12 as=1.496e-12 pd=9.48e-06 ps=9.48e-06 m=1
XN0[102] pad gate iovss sub! sg13_hv_nmos w=4.4u l=600.0n ng=1 ad=1.496e-12 as=1.496e-12 pd=9.48e-06 ps=9.48e-06 m=1
XN0[103] pad gate iovss sub! sg13_hv_nmos w=4.4u l=600.0n ng=1 ad=1.496e-12 as=1.496e-12 pd=9.48e-06 ps=9.48e-06 m=1
XN0[104] pad gate iovss sub! sg13_hv_nmos w=4.4u l=600.0n ng=1 ad=1.496e-12 as=1.496e-12 pd=9.48e-06 ps=9.48e-06 m=1
XN0[105] pad gate iovss sub! sg13_hv_nmos w=4.4u l=600.0n ng=1 ad=1.496e-12 as=1.496e-12 pd=9.48e-06 ps=9.48e-06 m=1
XN0[106] pad gate iovss sub! sg13_hv_nmos w=4.4u l=600.0n ng=1 ad=1.496e-12 as=1.496e-12 pd=9.48e-06 ps=9.48e-06 m=1
XN0[107] pad gate iovss sub! sg13_hv_nmos w=4.4u l=600.0n ng=1 ad=1.496e-12 as=1.496e-12 pd=9.48e-06 ps=9.48e-06 m=1
XN0[108] pad gate iovss sub! sg13_hv_nmos w=4.4u l=600.0n ng=1 ad=1.496e-12 as=1.496e-12 pd=9.48e-06 ps=9.48e-06 m=1
XN0[109] pad gate iovss sub! sg13_hv_nmos w=4.4u l=600.0n ng=1 ad=1.496e-12 as=1.496e-12 pd=9.48e-06 ps=9.48e-06 m=1
XN0[110] pad gate iovss sub! sg13_hv_nmos w=4.4u l=600.0n ng=1 ad=1.496e-12 as=1.496e-12 pd=9.48e-06 ps=9.48e-06 m=1
XN0[111] pad gate iovss sub! sg13_hv_nmos w=4.4u l=600.0n ng=1 ad=1.496e-12 as=1.496e-12 pd=9.48e-06 ps=9.48e-06 m=1
XN0[112] pad gate iovss sub! sg13_hv_nmos w=4.4u l=600.0n ng=1 ad=1.496e-12 as=1.496e-12 pd=9.48e-06 ps=9.48e-06 m=1
XN0[113] pad gate iovss sub! sg13_hv_nmos w=4.4u l=600.0n ng=1 ad=1.496e-12 as=1.496e-12 pd=9.48e-06 ps=9.48e-06 m=1
XN0[114] pad gate iovss sub! sg13_hv_nmos w=4.4u l=600.0n ng=1 ad=1.496e-12 as=1.496e-12 pd=9.48e-06 ps=9.48e-06 m=1
XN0[115] pad gate iovss sub! sg13_hv_nmos w=4.4u l=600.0n ng=1 ad=1.496e-12 as=1.496e-12 pd=9.48e-06 ps=9.48e-06 m=1
XN0[116] pad gate iovss sub! sg13_hv_nmos w=4.4u l=600.0n ng=1 ad=1.496e-12 as=1.496e-12 pd=9.48e-06 ps=9.48e-06 m=1
XN0[117] pad gate iovss sub! sg13_hv_nmos w=4.4u l=600.0n ng=1 ad=1.496e-12 as=1.496e-12 pd=9.48e-06 ps=9.48e-06 m=1
XN0[118] pad gate iovss sub! sg13_hv_nmos w=4.4u l=600.0n ng=1 ad=1.496e-12 as=1.496e-12 pd=9.48e-06 ps=9.48e-06 m=1
XN0[119] pad gate iovss sub! sg13_hv_nmos w=4.4u l=600.0n ng=1 ad=1.496e-12 as=1.496e-12 pd=9.48e-06 ps=9.48e-06 m=1
XN0[120] pad gate iovss sub! sg13_hv_nmos w=4.4u l=600.0n ng=1 ad=1.496e-12 as=1.496e-12 pd=9.48e-06 ps=9.48e-06 m=1
XN0[121] pad gate iovss sub! sg13_hv_nmos w=4.4u l=600.0n ng=1 ad=1.496e-12 as=1.496e-12 pd=9.48e-06 ps=9.48e-06 m=1
XN0[122] pad gate iovss sub! sg13_hv_nmos w=4.4u l=600.0n ng=1 ad=1.496e-12 as=1.496e-12 pd=9.48e-06 ps=9.48e-06 m=1
XN0[123] pad gate iovss sub! sg13_hv_nmos w=4.4u l=600.0n ng=1 ad=1.496e-12 as=1.496e-12 pd=9.48e-06 ps=9.48e-06 m=1
XN0[124] pad gate iovss sub! sg13_hv_nmos w=4.4u l=600.0n ng=1 ad=1.496e-12 as=1.496e-12 pd=9.48e-06 ps=9.48e-06 m=1
XN0[125] pad gate iovss sub! sg13_hv_nmos w=4.4u l=600.0n ng=1 ad=1.496e-12 as=1.496e-12 pd=9.48e-06 ps=9.48e-06 m=1
XN0[126] pad gate iovss sub! sg13_hv_nmos w=4.4u l=600.0n ng=1 ad=1.496e-12 as=1.496e-12 pd=9.48e-06 ps=9.48e-06 m=1
XN0[127] pad gate iovss sub! sg13_hv_nmos w=4.4u l=600.0n ng=1 ad=1.496e-12 as=1.496e-12 pd=9.48e-06 ps=9.48e-06 m=1
XN0[128] pad gate iovss sub! sg13_hv_nmos w=4.4u l=600.0n ng=1 ad=1.496e-12 as=1.496e-12 pd=9.48e-06 ps=9.48e-06 m=1
XN0[129] pad gate iovss sub! sg13_hv_nmos w=4.4u l=600.0n ng=1 ad=1.496e-12 as=1.496e-12 pd=9.48e-06 ps=9.48e-06 m=1
XN0[130] pad gate iovss sub! sg13_hv_nmos w=4.4u l=600.0n ng=1 ad=1.496e-12 as=1.496e-12 pd=9.48e-06 ps=9.48e-06 m=1
XN0[131] pad gate iovss sub! sg13_hv_nmos w=4.4u l=600.0n ng=1 ad=1.496e-12 as=1.496e-12 pd=9.48e-06 ps=9.48e-06 m=1
XN0[132] pad gate iovss sub! sg13_hv_nmos w=4.4u l=600.0n ng=1 ad=1.496e-12 as=1.496e-12 pd=9.48e-06 ps=9.48e-06 m=1
XN0[133] pad gate iovss sub! sg13_hv_nmos w=4.4u l=600.0n ng=1 ad=1.496e-12 as=1.496e-12 pd=9.48e-06 ps=9.48e-06 m=1
XN0[134] pad gate iovss sub! sg13_hv_nmos w=4.4u l=600.0n ng=1 ad=1.496e-12 as=1.496e-12 pd=9.48e-06 ps=9.48e-06 m=1
XN0[135] pad gate iovss sub! sg13_hv_nmos w=4.4u l=600.0n ng=1 ad=1.496e-12 as=1.496e-12 pd=9.48e-06 ps=9.48e-06 m=1
XN0[136] pad gate iovss sub! sg13_hv_nmos w=4.4u l=600.0n ng=1 ad=1.496e-12 as=1.496e-12 pd=9.48e-06 ps=9.48e-06 m=1
XN0[137] pad gate iovss sub! sg13_hv_nmos w=4.4u l=600.0n ng=1 ad=1.496e-12 as=1.496e-12 pd=9.48e-06 ps=9.48e-06 m=1
XN0[138] pad gate iovss sub! sg13_hv_nmos w=4.4u l=600.0n ng=1 ad=1.496e-12 as=1.496e-12 pd=9.48e-06 ps=9.48e-06 m=1
XN0[139] pad gate iovss sub! sg13_hv_nmos w=4.4u l=600.0n ng=1 ad=1.496e-12 as=1.496e-12 pd=9.48e-06 ps=9.48e-06 m=1
XN0[140] pad gate iovss sub! sg13_hv_nmos w=4.4u l=600.0n ng=1 ad=1.496e-12 as=1.496e-12 pd=9.48e-06 ps=9.48e-06 m=1
XN0[141] pad gate iovss sub! sg13_hv_nmos w=4.4u l=600.0n ng=1 ad=1.496e-12 as=1.496e-12 pd=9.48e-06 ps=9.48e-06 m=1
XN0[142] pad gate iovss sub! sg13_hv_nmos w=4.4u l=600.0n ng=1 ad=1.496e-12 as=1.496e-12 pd=9.48e-06 ps=9.48e-06 m=1
XN0[143] pad gate iovss sub! sg13_hv_nmos w=4.4u l=600.0n ng=1 ad=1.496e-12 as=1.496e-12 pd=9.48e-06 ps=9.48e-06 m=1
XN0[144] pad gate iovss sub! sg13_hv_nmos w=4.4u l=600.0n ng=1 ad=1.496e-12 as=1.496e-12 pd=9.48e-06 ps=9.48e-06 m=1
XN0[145] pad gate iovss sub! sg13_hv_nmos w=4.4u l=600.0n ng=1 ad=1.496e-12 as=1.496e-12 pd=9.48e-06 ps=9.48e-06 m=1
XN0[146] pad gate iovss sub! sg13_hv_nmos w=4.4u l=600.0n ng=1 ad=1.496e-12 as=1.496e-12 pd=9.48e-06 ps=9.48e-06 m=1
XN0[147] pad gate iovss sub! sg13_hv_nmos w=4.4u l=600.0n ng=1 ad=1.496e-12 as=1.496e-12 pd=9.48e-06 ps=9.48e-06 m=1
XN0[148] pad gate iovss sub! sg13_hv_nmos w=4.4u l=600.0n ng=1 ad=1.496e-12 as=1.496e-12 pd=9.48e-06 ps=9.48e-06 m=1
XN0[149] pad gate iovss sub! sg13_hv_nmos w=4.4u l=600.0n ng=1 ad=1.496e-12 as=1.496e-12 pd=9.48e-06 ps=9.48e-06 m=1
XN0[150] pad gate iovss sub! sg13_hv_nmos w=4.4u l=600.0n ng=1 ad=1.496e-12 as=1.496e-12 pd=9.48e-06 ps=9.48e-06 m=1
XN0[151] pad gate iovss sub! sg13_hv_nmos w=4.4u l=600.0n ng=1 ad=1.496e-12 as=1.496e-12 pd=9.48e-06 ps=9.48e-06 m=1
XN0[152] pad gate iovss sub! sg13_hv_nmos w=4.4u l=600.0n ng=1 ad=1.496e-12 as=1.496e-12 pd=9.48e-06 ps=9.48e-06 m=1
XN0[153] pad gate iovss sub! sg13_hv_nmos w=4.4u l=600.0n ng=1 ad=1.496e-12 as=1.496e-12 pd=9.48e-06 ps=9.48e-06 m=1
XN0[154] pad gate iovss sub! sg13_hv_nmos w=4.4u l=600.0n ng=1 ad=1.496e-12 as=1.496e-12 pd=9.48e-06 ps=9.48e-06 m=1
XN0[155] pad gate iovss sub! sg13_hv_nmos w=4.4u l=600.0n ng=1 ad=1.496e-12 as=1.496e-12 pd=9.48e-06 ps=9.48e-06 m=1
XN0[156] pad gate iovss sub! sg13_hv_nmos w=4.4u l=600.0n ng=1 ad=1.496e-12 as=1.496e-12 pd=9.48e-06 ps=9.48e-06 m=1
XN0[157] pad gate iovss sub! sg13_hv_nmos w=4.4u l=600.0n ng=1 ad=1.496e-12 as=1.496e-12 pd=9.48e-06 ps=9.48e-06 m=1
XN0[158] pad gate iovss sub! sg13_hv_nmos w=4.4u l=600.0n ng=1 ad=1.496e-12 as=1.496e-12 pd=9.48e-06 ps=9.48e-06 m=1
XN0[159] pad gate iovss sub! sg13_hv_nmos w=4.4u l=600.0n ng=1 ad=1.496e-12 as=1.496e-12 pd=9.48e-06 ps=9.48e-06 m=1
XN0[160] pad gate iovss sub! sg13_hv_nmos w=4.4u l=600.0n ng=1 ad=1.496e-12 as=1.496e-12 pd=9.48e-06 ps=9.48e-06 m=1
XN0[161] pad gate iovss sub! sg13_hv_nmos w=4.4u l=600.0n ng=1 ad=1.496e-12 as=1.496e-12 pd=9.48e-06 ps=9.48e-06 m=1
XN0[162] pad gate iovss sub! sg13_hv_nmos w=4.4u l=600.0n ng=1 ad=1.496e-12 as=1.496e-12 pd=9.48e-06 ps=9.48e-06 m=1
XN0[163] pad gate iovss sub! sg13_hv_nmos w=4.4u l=600.0n ng=1 ad=1.496e-12 as=1.496e-12 pd=9.48e-06 ps=9.48e-06 m=1
XN0[164] pad gate iovss sub! sg13_hv_nmos w=4.4u l=600.0n ng=1 ad=1.496e-12 as=1.496e-12 pd=9.48e-06 ps=9.48e-06 m=1
XN0[165] pad gate iovss sub! sg13_hv_nmos w=4.4u l=600.0n ng=1 ad=1.496e-12 as=1.496e-12 pd=9.48e-06 ps=9.48e-06 m=1
XN0[166] pad gate iovss sub! sg13_hv_nmos w=4.4u l=600.0n ng=1 ad=1.496e-12 as=1.496e-12 pd=9.48e-06 ps=9.48e-06 m=1
XN0[167] pad gate iovss sub! sg13_hv_nmos w=4.4u l=600.0n ng=1 ad=1.496e-12 as=1.496e-12 pd=9.48e-06 ps=9.48e-06 m=1
XN0[168] pad gate iovss sub! sg13_hv_nmos w=4.4u l=600.0n ng=1 ad=1.496e-12 as=1.496e-12 pd=9.48e-06 ps=9.48e-06 m=1
XN0[169] pad gate iovss sub! sg13_hv_nmos w=4.4u l=600.0n ng=1 ad=1.496e-12 as=1.496e-12 pd=9.48e-06 ps=9.48e-06 m=1
XN0[170] pad gate iovss sub! sg13_hv_nmos w=4.4u l=600.0n ng=1 ad=1.496e-12 as=1.496e-12 pd=9.48e-06 ps=9.48e-06 m=1
XN0[171] pad gate iovss sub! sg13_hv_nmos w=4.4u l=600.0n ng=1 ad=1.496e-12 as=1.496e-12 pd=9.48e-06 ps=9.48e-06 m=1
XN0[172] pad gate iovss sub! sg13_hv_nmos w=4.4u l=600.0n ng=1 ad=1.496e-12 as=1.496e-12 pd=9.48e-06 ps=9.48e-06 m=1
XR0 iovss sub! ptap1 R=9.999
XD0 sub! gate dantenna l=480n w=480n m=1
.ends
* End of subcircuit definition.

* Library name: sg13g2_io
* Cell name: sg13g2_RCClampResistor
* View name: schematic
.subckt sg13g2_RCClampResistor pin1 pin2
XR15 net15 net16 sub! rppd R=5.239K l=20u w=1u
XR20 net20 net21 sub! rppd R=5.239K l=20u w=1u
XR23 net23 net24 sub! rppd R=5.239K l=20u w=1u
XR17 net17 net18 sub! rppd R=5.239K l=20u w=1u
XR16 net16 net17 sub! rppd R=5.239K l=20u w=1u
XR25 net25 pin2 sub! rppd R=5.239K l=20u w=1u
XR22 net22 net23 sub! rppd R=5.239K l=20u w=1u
XR19 net19 net20 sub! rppd R=5.239K l=20u w=1u
XR24 net24 net25 sub! rppd R=5.239K l=20u w=1u
XR21 net21 net22 sub! rppd R=5.239K l=20u w=1u
XR18 net18 net19 sub! rppd R=5.239K l=20u w=1u
XR5 net5 net6 sub! rppd R=5.239K l=20u w=1u
XR8 net8 net9 sub! rppd R=5.239K l=20u w=1u
XR11 net11 net12 sub! rppd R=5.239K l=20u w=1u
XR14 net14 net15 sub! rppd R=5.239K l=20u w=1u
XR2 net2 net3 sub! rppd R=5.239K l=20u w=1u
XR1 net1 net2 sub! rppd R=5.239K l=20u w=1u
XR13 net13 net14 sub! rppd R=5.239K l=20u w=1u
XR10 net10 net11 sub! rppd R=5.239K l=20u w=1u
XR7 net7 net8 sub! rppd R=5.239K l=20u w=1u
XR4 net4 net5 sub! rppd R=5.239K l=20u w=1u
XR12 net12 net13 sub! rppd R=5.239K l=20u w=1u
XR9 net9 net10 sub! rppd R=5.239K l=20u w=1u
XR6 net6 net7 sub! rppd R=5.239K l=20u w=1u
XR3 net3 net4 sub! rppd R=5.239K l=20u w=1u
XR0 pin1 net1 sub! rppd R=5.239K l=20u w=1u
.ends
* End of subcircuit definition.

* Library name: sg13g2_io
* Cell name: sg13g2_RCClampInverter
* View name: schematic
.subckt sg13g2_RCClampInverter out in iovss supply
XN1 iovss in iovss sub! sg13_hv_nmos w=63.000u l=9.5u ng=7 ad=1.332e-11 as=1.332e-11 pd=7.496e-05 ps=7.496e-05 m=1
XN3 out in iovss sub! sg13_hv_nmos w=54.000u l=500.0n ng=6 ad=1.026e-11 as=1.296e-11 pd=5.628e-05 ps=7.488e-05 m=1
XN0 iovss in iovss sub! sg13_hv_nmos w=63.000u l=9.5u ng=7 ad=1.332e-11 as=1.332e-11 pd=7.496e-05 ps=7.496e-05 m=1
XN2 out in iovss sub! sg13_hv_nmos w=54.000u l=500.0n ng=6 ad=1.026e-11 as=1.296e-11 pd=5.628e-05 ps=7.488e-05 m=1
XR0 iovss sub! ptap1 R=9.59
XP0 out in supply supply sg13_hv_pmos w=350.000u l=500.0n ng=50 ad=6.65e-11 as=6.86e-11 pd=0.000369 ps=0.0003836 m=1
.ends
* End of subcircuit definition.

* Library name: sg13g2_io
* Cell name: sg13g2_IOPadVdd
* View name: schematic
.subckt sg13g2_IOPadVdd vdd vss iovdd iovss
XI1 net3 iovss vdd sg13g2_Clamp_N43N43D4R
XI4 vdd net1 sg13g2_RCClampResistor
XR1 iovss sub! ptap1 R=456.33m
XR0 vss sub! ptap1 R=22.472
XI3 net3 net1 iovss vdd sg13g2_RCClampInverter
.ends
* End of subcircuit definition.

* Library name: sg13g2_io
* Cell name: sg13g2_IOPadIOVdd
* View name: schematic
.subckt sg13g2_IOPadIOVdd vdd vss iovdd iovss
XI1 net4 iovss iovdd sg13g2_Clamp_N43N43D4R
XI3 iovdd net1 sg13g2_RCClampResistor
XI2 net4 net1 iovss iovdd sg13g2_RCClampInverter
XR1 iovss sub! ptap1 R=453.388m
XR0 vss sub! ptap1 R=22.472
.ends
* End of subcircuit definition.

* Library name: sg13g2_io
* Cell name: sg13g2_IOPadVss
* View name: schematic
.subckt sg13g2_IOPadVss vdd vss iovdd iovss
XI1 iovss vss iovdd sg13g2_DCNDiode
XI2 vss iovdd iovss sg13g2_DCPDiode
XR1 iovss sub! ptap1 R=174.346m
XR0 vss sub! ptap1 R=22.832
.ends
* End of subcircuit definition.

* Library name: sg13g2_io
* Cell name: sg13g2_Filler2000
* View name: schematic
.subckt sg13g2_Filler2000 vdd vss iovdd iovss
XR1 vss sub! ptap1 R=101.912
XR0 iovss sub! ptap1 R=1.224
.ends
* End of subcircuit definition.

* Library name: sg13g2_io
* Cell name: sg13g2_io_inv_x1
* View name: schematic
.subckt sg13g2_io_inv_x1 nq i vdd vss
XN0 nq i vss sub! sg13_lv_nmos w=3.93u l=130.00n ng=1 ad=1.336e-12 as=1.336e-12 pd=8.54e-06 ps=8.54e-06 m=1
XP0 nq i vdd vdd sg13_lv_pmos w=4.41u l=130.00n ng=1 ad=1.499e-12 as=1.499e-12 pd=9.5e-06 ps=9.5e-06 m=1
XR0 vss sub! ptap1 R=258.978
.ends
* End of subcircuit definition.

* Library name: sg13g2_io
* Cell name: sg13g2_LevelUp
* View name: schematic
.subckt sg13g2_LevelUp o i iovdd vdd vss
XN1 net2 i vss sub! sg13_lv_nmos w=2.75u l=130.00n ng=1 ad=9.35e-13 as=9.35e-13 pd=6.18e-06 ps=6.18e-06 m=1
XP3 net2 i vdd vdd sg13_lv_pmos w=4.75u l=130.00n ng=1 ad=1.615e-12 as=1.615e-12 pd=1.018e-05 ps=1.018e-05 m=1
XN0 o net4 vss sub! sg13_hv_nmos w=1.9u l=450.00n ng=1 ad=0.0 as=0.0 pd=0.0 ps=0.0 m=1
XN3 net4 i vss sub! sg13_hv_nmos w=1.9u l=450.00n ng=1 ad=0.0 as=0.0 pd=0.0 ps=0.0 m=1
XN2 net3 net2 vss sub! sg13_hv_nmos w=1.9u l=450.00n ng=1 ad=0.0 as=0.0 pd=0.0 ps=0.0 m=1
XP0 o net4 iovdd iovdd sg13_hv_pmos w=3.9u l=450.00n ng=1 ad=1.326e-12 as=1.326e-12 pd=8.48e-06 ps=8.48e-06 m=1
XP1 net3 net4 iovdd iovdd sg13_hv_pmos w=300.0n l=450.00n ng=1 ad=1.02e-13 as=1.02e-13 pd=1.28e-06 ps=1.28e-06 m=1
XP2 net4 net3 iovdd iovdd sg13_hv_pmos w=300.0n l=450.00n ng=1 ad=0.0 as=0.0 pd=0.0 ps=0.0 m=1
XR0 vss sub! ptap1 R=207.099
.ends
* End of subcircuit definition.

* Library name: sg13g2_io
* Cell name: sg13g2_io_nor2_x1
* View name: schematic
.subckt sg13g2_io_nor2_x1 nq i0 i1 vdd vss
XN0 nq i0 vss sub! sg13_lv_nmos w=3.93u l=130.00n ng=1 ad=1.336e-12 as=1.336e-12 pd=8.54e-06 ps=8.54e-06 m=1
XN1 nq i1 vss sub! sg13_lv_nmos w=3.93u l=130.00n ng=1 ad=1.336e-12 as=1.336e-12 pd=8.54e-06 ps=8.54e-06 m=1
XP0 net1 i0 vdd vdd sg13_lv_pmos w=4.41u l=130.00n ng=1 ad=1.499e-12 as=1.499e-12 pd=9.5e-06 ps=9.5e-06 m=1
XP1 nq i1 net1 vdd sg13_lv_pmos w=4.41u l=130.00n ng=1 ad=1.499e-12 as=1.499e-12 pd=9.5e-06 ps=9.5e-06 m=1
XR0 vss sub! ptap1 R=251.534
.ends
* End of subcircuit definition.

* Library name: sg13g2_io
* Cell name: sg13g2_io_tie
* View name: schematic
.subckt sg13g2_io_tie vdd vss
XR0 vss sub! ptap1 R=258.978
.ends
* End of subcircuit definition.

* Library name: sg13g2_io
* Cell name: sg13g2_io_nand2_x1
* View name: schematic
.subckt sg13g2_io_nand2_x1 nq i0 i1 vdd vss
XP1 nq i1 vdd vdd sg13_lv_pmos w=4.41u l=130.00n ng=1 ad=1.499e-12 as=1.499e-12 pd=9.5e-06 ps=9.5e-06 m=1
XP0 nq i0 vdd vdd sg13_lv_pmos w=4.41u l=130.00n ng=1 ad=1.499e-12 as=1.499e-12 pd=9.5e-06 ps=9.5e-06 m=1
XN1 net1 i0 vss sub! sg13_lv_nmos w=3.93u l=130.00n ng=1 ad=1.336e-12 as=1.336e-12 pd=8.54e-06 ps=8.54e-06 m=1
XN0 nq i1 net1 sub! sg13_lv_nmos w=3.93u l=130.00n ng=1 ad=1.336e-12 as=1.336e-12 pd=8.54e-06 ps=8.54e-06 m=1
XR0 vss sub! ptap1 R=251.534
.ends
* End of subcircuit definition.

* Library name: sg13g2_io
* Cell name: sg13g2_GateDecode
* View name: schematic
.subckt sg13g2_GateDecode ngate pgate core en iovdd vdd vss
XI1 net3 en vdd vss sg13g2_io_inv_x1
XI4 ngate net4 iovdd vdd vss sg13g2_LevelUp
XI2 pgate net2 iovdd vdd vss sg13g2_LevelUp
XI3 net4 core net3 vdd vss sg13g2_io_nor2_x1
XI0 vdd vss sg13g2_io_tie
XI5 net2 core en vdd vss sg13g2_io_nand2_x1
.ends
* End of subcircuit definition.

* Library name: sg13g2_io
* Cell name: sg13g2_Clamp_N2N2D
* View name: schematic
.subckt sg13g2_Clamp_N2N2D gate iovss pad
XR0 iovss sub! ptap1 R=11.438
XN1 pad gate iovss sub! sg13_hv_nmos w=8.8u l=600.0n ng=2 ad=1.672e-12 as=2.992e-12 pd=9.56e-06 ps=1.896e-05 m=1
XD0 sub! gate dantenna l=780.00n w=780.00n m=1
.ends
* End of subcircuit definition.

* Library name: sg13g2_io
* Cell name: sg13g2_Clamp_P2N2D
* View name: schematic
.subckt sg13g2_Clamp_P2N2D gate iovdd iovss pad
XD0 gate iovdd dpantenna l=480n w=480n m=1
XP1 pad gate iovdd iovdd sg13_hv_pmos w=13.32u l=600.0n ng=2 ad=2.531e-12 as=4.529e-12 pd=1.408e-05 ps=2.8e-05 m=1
XP0 pad gate iovdd iovdd sg13_hv_pmos w=13.32u l=600.0n ng=2 ad=2.531e-12 as=4.529e-12 pd=1.408e-05 ps=2.8e-05 m=1
XR0 iovss sub! ptap1 R=9.826
.ends
* End of subcircuit definition.

* Library name: sg13g2_io
* Cell name: sg13g2_SecondaryProtection
* View name: schematic
.subckt sg13g2_SecondaryProtection core minus pad plus
XR0 pad core sub! rppd R=586.899 l=2u w=1u
XD1 sub! core dantenna l=3.1u w=640n m=1
XR1 minus sub! ptap1 R=46.556
XD0 core plus dpantenna l=4.98u w=640n m=1
.ends
* End of subcircuit definition.

* Library name: sg13g2_io
* Cell name: sg13g2_LevelDown
* View name: schematic
.subckt sg13g2_LevelDown core pad iovdd iovss vdd vss
XP0 vdd vdd vdd vdd sg13_hv_pmos w=4.65u l=450.00n ng=1 ad=1.581e-12 as=1.581e-12 pd=9.98e-06 ps=9.98e-06 m=1
XP2 net4 net7 iovdd iovdd sg13_hv_pmos w=4.6u l=450.00n ng=2 ad=8.74e-13 as=1.564e-12 pd=5.36e-06 ps=1.056e-05 m=1
XP3 net7 net1 iovdd iovdd sg13_hv_pmos w=4.6u l=450.00n ng=2 ad=8.74e-13 as=1.564e-12 pd=5.36e-06 ps=1.056e-05 m=1
XN3 net4 net7 iovss sub! sg13_hv_nmos w=1.3u l=450.00n ng=1 ad=4.42e-13 as=4.42e-13 pd=3.28e-06 ps=3.28e-06 m=1
XN4 net7 net1 iovss sub! sg13_hv_nmos w=1.3u l=450.00n ng=1 ad=4.42e-13 as=4.42e-13 pd=3.28e-06 ps=3.28e-06 m=1
XN2 net2 net4 vss sub! sg13_hv_nmos w=2.65u l=450.00n ng=1 ad=9.01e-13 as=9.01e-13 pd=5.98e-06 ps=5.98e-06 m=1
XN0 vdd net7 net2 sub! sg13_hv_nmos w=2.65u l=450.00n ng=1 ad=9.01e-13 as=9.01e-13 pd=5.98e-06 ps=5.98e-06 m=1
XN1 core net2 vss sub! sg13_lv_nmos w=2.75u l=130.00n ng=1 ad=9.35e-13 as=9.35e-13 pd=6.18e-06 ps=6.18e-06 m=1
XP1 core net2 vdd vdd sg13_lv_pmos w=4.75u l=130.00n ng=1 ad=1.615e-12 as=1.615e-12 pd=1.018e-05 ps=1.018e-05 m=1
XR1 iovss sub! ptap1 R=199.584
XR0 vss sub! ptap1 R=127.332
XI0 net1 iovss pad iovdd sg13g2_SecondaryProtection
.ends
* End of subcircuit definition.

* Library name: sg13g2_io
* Cell name: sg13g2_IOPadInOut4mA
* View name: schematic
.subckt sg13g2_IOPadInOut4mA pad c2p p2c c2p_en vdd vss iovdd iovss
XI1 pad iovdd iovss sg13g2_DCPDiode
XI2 net2 net1 c2p c2p_en iovdd vdd vss sg13g2_GateDecode
XI3 net2 iovss pad sg13g2_Clamp_N2N2D
XI0 net1 iovdd iovss pad sg13g2_Clamp_P2N2D
XI4 p2c pad iovdd iovss vdd vss sg13g2_LevelDown
XR0 vss sub! ptap1 R=26.933
XR1 iovss sub! ptap1 R=214.134m
XI5 iovss pad iovdd sg13g2_DCNDiode
.ends
* End of subcircuit definition.

* Library name: sg13g2_io
* Cell name: sg13g2_Clamp_P15N15D
* View name: schematic
.subckt sg13g2_Clamp_P15N15D gate iovdd iovss pad
XD0 gate iovdd dpantenna l=780.00n w=780.00n m=1
XR0 iovss sub! ptap1 R=9.826
XP1 pad gate iovdd iovdd sg13_hv_pmos w=99.9u l=600.0n ng=15 ad=1.998e-11 as=1.998e-11 pd=0.0001126 ps=0.0001126 m=1
XP0 pad gate iovdd iovdd sg13_hv_pmos w=99.9u l=600.0n ng=15 ad=1.998e-11 as=1.998e-11 pd=0.0001126 ps=0.0001126 m=1
.ends
* End of subcircuit definition.

* Library name: sg13g2_io
* Cell name: sg13g2_Clamp_N15N15D
* View name: schematic
.subckt sg13g2_Clamp_N15N15D gate iovss pad
XR0 iovss sub! ptap1 R=11.438
XN0 pad gate iovss sub! sg13_hv_nmos w=66.000u l=600.0n ng=15 ad=1.32e-11 as=1.32e-11 pd=7.64e-05 ps=7.64e-05 m=1
XD0 sub! gate dantenna l=780.00n w=780.00n m=1
.ends
* End of subcircuit definition.

* Library name: sg13g2_io
* Cell name: sg13g2_IOPadInOut30mA
* View name: schematic
.subckt sg13g2_IOPadInOut30mA pad c2p p2c c2p_en vdd vss iovdd iovss
XI4 p2c pad iovdd iovss vdd vss sg13g2_LevelDown
XI1 pad iovdd iovss sg13g2_DCPDiode
XI0 net1 iovdd iovss pad sg13g2_Clamp_P15N15D
XI5 iovss pad iovdd sg13g2_DCNDiode
XI3 net2 iovss pad sg13g2_Clamp_N15N15D
XR0 vss sub! ptap1 R=26.746
XR1 iovss sub! ptap1 R=214.165m
XI2 net2 net1 c2p c2p_en iovdd vdd vss sg13g2_GateDecode
.ends
* End of subcircuit definition.

* Library name: sg13g2_io
* Cell name: sg13g2_LevelUpInv
* View name: schematic
.subckt sg13g2_LevelUpInv o i iovdd vdd vss
XN1 net2 i vss sub! sg13_lv_nmos w=2.75u l=130.00n ng=1 ad=9.35e-13 as=9.35e-13 pd=6.18e-06 ps=6.18e-06 m=1
XP3 net2 i vdd vdd sg13_lv_pmos w=4.75u l=130.00n ng=1 ad=1.615e-12 as=1.615e-12 pd=1.018e-05 ps=1.018e-05 m=1
XN0 o net4 vss sub! sg13_hv_nmos w=1.9u l=450.00n ng=1 ad=0.0 as=0.0 pd=0.0 ps=0.0 m=1
XN3 net4 net2 vss sub! sg13_hv_nmos w=1.9u l=450.00n ng=1 ad=0.0 as=0.0 pd=0.0 ps=0.0 m=1
XN2 net3 i vss sub! sg13_hv_nmos w=1.9u l=450.00n ng=1 ad=0.0 as=0.0 pd=0.0 ps=0.0 m=1
XP0 o net4 iovdd iovdd sg13_hv_pmos w=3.9u l=450.00n ng=1 ad=1.326e-12 as=1.326e-12 pd=8.48e-06 ps=8.48e-06 m=1
XP1 net3 net4 iovdd iovdd sg13_hv_pmos w=300.0n l=450.00n ng=1 ad=1.02e-13 as=1.02e-13 pd=1.28e-06 ps=1.28e-06 m=1
XP2 net4 net3 iovdd iovdd sg13_hv_pmos w=300.0n l=450.00n ng=1 ad=0.0 as=0.0 pd=0.0 ps=0.0 m=1
XR0 vss sub! ptap1 R=190.268
.ends
* End of subcircuit definition.

* Library name: sg13g2_io
* Cell name: sg13g2_GateLevelUpInv
* View name: schematic
.subckt sg13g2_GateLevelUpInv ngate pgate iovdd core vdd vss
XI1 pgate core iovdd vdd vss sg13g2_LevelUpInv
XI0 ngate core iovdd vdd vss sg13g2_LevelUpInv
.ends
* End of subcircuit definition.

* Library name: sg13g2_io
* Cell name: sg13g2_IOPadOut4mA
* View name: schematic
.subckt sg13g2_IOPadOut4mA pad c2p vdd vss iovdd iovss
XI2 net2 net1 iovdd c2p vdd vss sg13g2_GateLevelUpInv
XI0 net1 iovdd iovss pad sg13g2_Clamp_P2N2D
XI3 net2 iovss pad sg13g2_Clamp_N2N2D
XI4 iovss pad iovdd sg13g2_DCNDiode
XI1 pad iovdd iovss sg13g2_DCPDiode
XR1 iovss sub! ptap1 R=212.747m
XR0 vss sub! ptap1 R=24.125
.ends
* End of subcircuit definition.

* Library name: sg13g2_io
* Cell name: sg13g2_IOPadOut30mA
* View name: schematic
.subckt sg13g2_IOPadOut30mA pad c2p vdd vss iovdd iovss
XI2 net2 net1 iovdd c2p vdd vss sg13g2_GateLevelUpInv
XI1 net1 iovdd iovss pad sg13g2_Clamp_P15N15D
XI3 net2 iovss pad sg13g2_Clamp_N15N15D
XI4 iovss pad iovdd sg13g2_DCNDiode
XI0 pad iovdd iovss sg13g2_DCPDiode
XR0 vss sub! ptap1 R=24.125
XR1 iovss sub! ptap1 R=214.165m
.ends
* End of subcircuit definition.

* Library name: sg13g2_io
* Cell name: sg13g2_IOPadIn
* View name: schematic
.subckt sg13g2_IOPadIn pad p2c vdd vss iovdd iovss
XI0 p2c pad iovdd iovss vdd vss sg13g2_LevelDown
XI2 iovss pad iovdd sg13g2_DCNDiode
XI1 pad iovdd iovss sg13g2_DCPDiode
XR0 vss sub! ptap1 R=24.69
XR1 iovss sub! ptap1 R=173.674m
.ends
* End of subcircuit definition.

* Library name: sg13g2_io
* Cell name: sg13g2_Clamp_P8N8D
* View name: schematic
.subckt sg13g2_Clamp_P8N8D gate iovdd iovss pad
XR0 iovss sub! ptap1 R=9.826
XP2 pad gate iovdd iovdd sg13_hv_pmos w=53.28u l=600.0n ng=8 ad=1.012e-11 as=1.212e-11 pd=5.632e-05 ps=7.024e-05 m=1
XP0 pad gate iovdd iovdd sg13_hv_pmos w=53.28u l=600.0n ng=8 ad=1.012e-11 as=1.212e-11 pd=5.632e-05 ps=7.024e-05 m=1
XD0 gate iovdd dpantenna l=480n w=480n m=1
.ends
* End of subcircuit definition.

* Library name: sg13g2_io
* Cell name: sg13g2_Clamp_N8N8D
* View name: schematic
.subckt sg13g2_Clamp_N8N8D gate iovss pad
XR0 iovss sub! ptap1 R=11.438
XN0 pad gate iovss sub! sg13_hv_nmos w=35.2u l=600.0n ng=8 ad=6.688e-12 as=8.008e-12 pd=3.824e-05 ps=4.764e-05 m=1
XD0 sub! gate dantenna l=780.00n w=780.00n m=1
.ends
* End of subcircuit definition.

* Library name: sg13g2_io
* Cell name: sg13g2_IOPadInOut16mA
* View name: schematic
.subckt sg13g2_IOPadInOut16mA pad c2p p2c c2p_en vdd vss iovdd iovss
XI1 pad iovdd iovss sg13g2_DCPDiode
XI2 net2 net1 c2p c2p_en iovdd vdd vss sg13g2_GateDecode
XI5 iovss pad iovdd sg13g2_DCNDiode
XI0 net1 iovdd iovss pad sg13g2_Clamp_P8N8D
XI4 p2c pad iovdd iovss vdd vss sg13g2_LevelDown
XI3 net2 iovss pad sg13g2_Clamp_N8N8D
XR0 vss sub! ptap1 R=26.933
XR1 iovss sub! ptap1 R=207.756m
.ends
* End of subcircuit definition.

* Library name: sg13g2_io
* Cell name: sg13g2_IOPadOut16mA
* View name: schematic
.subckt sg13g2_IOPadOut16mA pad c2p vdd vss iovdd iovss
XI2 net2 net1 iovdd c2p vdd vss sg13g2_GateLevelUpInv
XI0 net1 iovdd iovss pad sg13g2_Clamp_P8N8D
XI4 iovss pad iovdd sg13g2_DCNDiode
XI3 net2 iovss pad sg13g2_Clamp_N8N8D
XI1 pad iovdd iovss sg13g2_DCPDiode
XR0 vss sub! ptap1 R=23.888
XR1 iovss sub! ptap1 R=208.667m
.ends
* End of subcircuit definition.

* Library name: sg13g2_io
* Cell name: sg13g2_IOPadTriOut4mA
* View name: schematic
.subckt sg13g2_IOPadTriOut4mA pad c2p c2p_en vdd vss iovdd iovss
XI2 net2 net1 c2p c2p_en iovdd vdd vss sg13g2_GateDecode
XI4 iovss pad iovdd sg13g2_DCNDiode
XI3 net2 iovss pad sg13g2_Clamp_N2N2D
XI0 net1 iovdd iovss pad sg13g2_Clamp_P2N2D
XI1 pad iovdd iovss sg13g2_DCPDiode
XR0 vss sub! ptap1 R=24.567
XR1 iovss sub! ptap1 R=208.667m
.ends
* End of subcircuit definition.

* Library name: sg13g2_io
* Cell name: sg13g2_IOPadTriOut16mA
* View name: schematic
.subckt sg13g2_IOPadTriOut16mA pad c2p c2p_en vdd vss iovdd iovss
XI2 net2 net1 c2p c2p_en iovdd vdd vss sg13g2_GateDecode
XI0 net1 iovdd iovss pad sg13g2_Clamp_P8N8D
XI3 net2 iovss pad sg13g2_Clamp_N8N8D
XI4 iovss pad iovdd sg13g2_DCNDiode
XI1 pad iovdd iovss sg13g2_DCPDiode
XR0 vss sub! ptap1 R=24.897
XR1 iovss sub! ptap1 R=208.211m
.ends
* End of subcircuit definition.

* Library name: sg13g2_io
* Cell name: sg13g2_IOPadTriOut30mA
* View name: schematic
.subckt sg13g2_IOPadTriOut30mA pad c2p c2p_en vdd vss iovdd iovss
XI2 net2 net1 c2p c2p_en iovdd vdd vss sg13g2_GateDecode
XI4 iovss pad iovdd sg13g2_DCNDiode
XI3 net2 iovss pad sg13g2_Clamp_N15N15D
XI0 net1 iovdd iovss pad sg13g2_Clamp_P15N15D
XI1 pad iovdd iovss sg13g2_DCPDiode
XR0 vss sub! ptap1 R=24.649
XR1 iovss sub! ptap1 R=208.667m
.ends
* End of subcircuit definition.

* Library name: sg13g2_io
* Cell name: sg13g2_Corner
* View name: schematic
.subckt sg13g2_Corner vdd vss iovdd iovss
XR1 vss sub! ptap1 R=35.383
XR0 iovss sub! ptap1 R=93.041m
.ends
* End of subcircuit definition.

* Library name: sg13g2_io
* Cell name: sg13g2_Filler4000
* View name: schematic
.subckt sg13g2_Filler4000 vdd vss iovdd iovss
XR1 vss sub! ptap1 R=63.078
XR0 iovss sub! ptap1 R=625.742m
.ends
* End of subcircuit definition.

* Library name: sg13g2_io
* Cell name: sg13g2_Filler1000
* View name: schematic
.subckt sg13g2_Filler1000 vdd vss iovdd iovss
XR1 vss sub! ptap1 R=162.013
XR0 iovss sub! ptap1 R=2.443
.ends
* End of subcircuit definition.

* Library name: sg13g2_io
* Cell name: sg13g2_Filler200
* View name: schematic
.subckt sg13g2_Filler200 vdd vss iovdd iovss
XR1 vss sub! ptap1 R=246.192
XR0 iovss sub! ptap1 R=14.724
.ends
* End of subcircuit definition.

* Library name: sg13g2_io
* Cell name: sg13g2_Filler400
* View name: schematic
.subckt sg13g2_Filler400 vdd vss iovdd iovss
XR1 vss sub! ptap1 R=246.192
XR0 iovss sub! ptap1 R=6.246
.ends
* End of subcircuit definition.

* Library name: sg13g2_io
* Cell name: sg13g2_Filler10000
* View name: schematic
.subckt sg13g2_Filler10000 vdd vss iovdd iovss
XR1 vss sub! ptap1 R=32.364
XR0 iovss sub! ptap1 R=253.731m
.ends sg13g2_Filler10000
* End of subcircuit definition.

* Library name: sg13g2_io
* Cell name: sg13g2_Clamp_P20N0D
* View name: schematic
.subckt sg13g2_Clamp_P20N0D iovdd iovss pad
XP1 pad net2 iovdd iovdd sg13_hv_pmos w=133.2u l=600.0n ng=20 ad=2.531e-11 as=2.731e-11 pd=0.0001408 ps=0.0001547 m=1
XP0 pad net2 iovdd iovdd sg13_hv_pmos w=133.2u l=600.0n ng=20 ad=2.531e-11 as=2.731e-11 pd=0.0001408 ps=0.0001547 m=1
XR0 net2 iovdd iovdd rppd R=6.768K l=12.9u w=500n
XR1 iovss sub! ptap1 R=9.826
.ends
* End of subcircuit definition.

* Library name: sg13g2_io
* Cell name: sg13g2_Clamp_N20N0D
* View name: schematic
.subckt sg13g2_Clamp_N20N0D iovss pad
XN0 pad net2 iovss sub! sg13_hv_nmos w=88.000u l=600.0n ng=20 ad=1.672e-11 as=1.804e-11 pd=9.56e-05 ps=0.000105 m=1
XR1 iovss sub! ptap1 R=11.438
XR0 iovss net2 sub! rppd R=1.959K l=3.54u w=500n
.ends
* End of subcircuit definition.

* Library name: sg13g2_io
* Cell name: sg13g2_IOPadAnalog
* View name: schematic
.subckt sg13g2_IOPadAnalog pad padres vdd vss iovdd iovss
XI0 iovdd iovss pad sg13g2_Clamp_P20N0D
XI5 iovss pad iovdd sg13g2_DCNDiode
XI2 pad iovdd iovss sg13g2_DCPDiode
XI3 padres iovss pad iovdd sg13g2_SecondaryProtection
XI4 iovss pad sg13g2_Clamp_N20N0D
XR0 vss sub! ptap1 R=22.579
XR1 iovss sub! ptap1 R=214.8m
.ends
* End of subcircuit definition.
