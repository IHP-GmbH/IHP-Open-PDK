************************************************************************
*
* sg13g2_stdcell_hv -- thick-oxide (3.3 V) standard cell library
*
* Derived from the IHP SG13G2 sg13g2_stdcell thin-oxide library by
* substituting the 3.3 V thick-oxide devices. Topology, pin names and pin
* order are unchanged from the thin-oxide cells.
*
*   model   sg13_lv_{n,p}mos -> sg13_hv_{n,p}mos
*   length  L -> max(L, 450 nm)     DRC Gat.a3, min gate length of the 3.3 V FET
*   width   NMOS unchanged; PMOS x 2.4
*           so the inverter switching threshold stays at Vm/VDD = 0.5046,
*           the value the thin-oxide library is sized to
*   as/ad/ps/pd recomputed from the HV model deck geometry (z1=0.34u, z2=0.38u)
*
* Generated 2026-08-03 by work/gen_hv_lib.py
*
* Original library Copyright 2023 IHP PDK Authors, Apache License 2.0.
* This derived work is distributed under the same terms.
*
************************************************************************

* Library name: sg13g2_stdcell_hv
* Cell name: sg13g2_hv_a21o_1
* View name: schematic
.subckt sg13g2_hv_a21o_1 X A1 A2 B1 VDD VSS
XN0 net1 A1 net2 VSS sg13_hv_nmos w=0.640u l=0.450u ng=1 ad=2.176e-13 as=2.176e-13 pd=1.96e-06 ps=1.96e-06 m=1
XN1 net2 A2 VSS VSS sg13_hv_nmos w=0.640u l=0.450u ng=1 ad=2.176e-13 as=2.176e-13 pd=1.96e-06 ps=1.96e-06 m=1
XN2 net1 B1 VSS VSS sg13_hv_nmos w=0.640u l=0.450u ng=1 ad=2.176e-13 as=2.176e-13 pd=1.96e-06 ps=1.96e-06 m=1
XN3 X net1 VSS VSS sg13_hv_nmos w=0.740u l=0.450u ng=1 ad=2.516e-13 as=2.516e-13 pd=2.16e-06 ps=2.16e-06 m=1
XP2 net1 B1 net3 VDD sg13_hv_pmos w=2.400u l=0.450u ng=1 ad=8.16e-13 as=8.16e-13 pd=5.48e-06 ps=5.48e-06 m=1
XP0 net3 A1 VDD VDD sg13_hv_pmos w=2.400u l=0.450u ng=1 ad=8.16e-13 as=8.16e-13 pd=5.48e-06 ps=5.48e-06 m=1
XP1 net3 A2 VDD VDD sg13_hv_pmos w=2.400u l=0.450u ng=1 ad=8.16e-13 as=8.16e-13 pd=5.48e-06 ps=5.48e-06 m=1
XP3 X net1 VDD VDD sg13_hv_pmos w=2.690u l=0.450u ng=1 ad=9.146e-13 as=9.146e-13 pd=6.06e-06 ps=6.06e-06 m=1
.ends
* End of subcircuit definition.

* Library name: sg13g2_stdcell_hv
* Cell name: sg13g2_hv_a21o_2
* View name: schematic
.subckt sg13g2_hv_a21o_2 X A1 A2 B1 VDD VSS
XN0 net1 A1 net2 VSS sg13_hv_nmos w=0.740u l=0.450u ng=1 ad=2.516e-13 as=2.516e-13 pd=2.16e-06 ps=2.16e-06 m=1
XN1 net2 A2 VSS VSS sg13_hv_nmos w=0.740u l=0.450u ng=1 ad=2.516e-13 as=2.516e-13 pd=2.16e-06 ps=2.16e-06 m=1
XN2 net1 B1 VSS VSS sg13_hv_nmos w=0.740u l=0.450u ng=1 ad=2.516e-13 as=2.516e-13 pd=2.16e-06 ps=2.16e-06 m=1
XN3 X net1 VSS VSS sg13_hv_nmos w=1.480u l=0.450u ng=2 ad=2.812e-13 as=5.032e-13 pd=2.24e-06 ps=4.32e-06 m=1
XP2 net1 B1 net3 VDD sg13_hv_pmos w=2.400u l=0.450u ng=1 ad=8.16e-13 as=8.16e-13 pd=5.48e-06 ps=5.48e-06 m=1
XP0 net3 A1 VDD VDD sg13_hv_pmos w=2.400u l=0.450u ng=1 ad=8.16e-13 as=8.16e-13 pd=5.48e-06 ps=5.48e-06 m=1
XP1 net3 A2 VDD VDD sg13_hv_pmos w=2.400u l=0.450u ng=1 ad=8.16e-13 as=8.16e-13 pd=5.48e-06 ps=5.48e-06 m=1
XP3 X net1 VDD VDD sg13_hv_pmos w=5.380u l=0.450u ng=2 ad=1.0222e-12 as=1.8292e-12 pd=6.14e-06 ps=1.212e-05 m=1
.ends
* End of subcircuit definition.

* Library name: sg13g2_stdcell_hv
* Cell name: sg13g2_hv_a21oi_1
* View name: schematic
.subckt sg13g2_hv_a21oi_1 Y A1 A2 B1 VDD VSS
XN0 Y B1 VSS VSS sg13_hv_nmos w=0.740u l=0.450u ng=1 ad=2.516e-13 as=2.516e-13 pd=2.16e-06 ps=2.16e-06 m=1
XN2 net1 A2 VSS VSS sg13_hv_nmos w=0.740u l=0.450u ng=1 ad=2.516e-13 as=2.516e-13 pd=2.16e-06 ps=2.16e-06 m=1
XN1 Y A1 net1 VSS sg13_hv_nmos w=0.740u l=0.450u ng=1 ad=2.516e-13 as=2.516e-13 pd=2.16e-06 ps=2.16e-06 m=1
XP2 Y B1 net2 VDD sg13_hv_pmos w=2.690u l=0.450u ng=1 ad=9.146e-13 as=9.146e-13 pd=6.06e-06 ps=6.06e-06 m=1
XP1 net2 A2 VDD VDD sg13_hv_pmos w=2.690u l=0.450u ng=1 ad=9.146e-13 as=9.146e-13 pd=6.06e-06 ps=6.06e-06 m=1
XP0 net2 A1 VDD VDD sg13_hv_pmos w=2.690u l=0.450u ng=1 ad=9.146e-13 as=9.146e-13 pd=6.06e-06 ps=6.06e-06 m=1
.ends
* End of subcircuit definition.

* Library name: sg13g2_stdcell_hv
* Cell name: sg13g2_hv_a21oi_2
* View name: schematic
.subckt sg13g2_hv_a21oi_2 Y A1 A2 B1 VDD VSS
XN0 Y B1 VSS VSS sg13_hv_nmos w=1.480u l=0.450u ng=2 ad=2.812e-13 as=5.032e-13 pd=2.24e-06 ps=4.32e-06 m=1
XN2 net2 A2 VSS VSS sg13_hv_nmos w=1.480u l=0.450u ng=2 ad=2.812e-13 as=5.032e-13 pd=2.24e-06 ps=4.32e-06 m=1
XN1 Y A1 net2 VSS sg13_hv_nmos w=1.480u l=0.450u ng=2 ad=2.812e-13 as=5.032e-13 pd=2.24e-06 ps=4.32e-06 m=1
XP2 Y B1 net1 VDD sg13_hv_pmos w=5.380u l=0.450u ng=2 ad=1.0222e-12 as=1.8292e-12 pd=6.14e-06 ps=1.212e-05 m=1
XP1 net1 A2 VDD VDD sg13_hv_pmos w=5.380u l=0.450u ng=2 ad=1.0222e-12 as=1.8292e-12 pd=6.14e-06 ps=1.212e-05 m=1
XP0 net1 A1 VDD VDD sg13_hv_pmos w=5.380u l=0.450u ng=2 ad=1.0222e-12 as=1.8292e-12 pd=6.14e-06 ps=1.212e-05 m=1
.ends
* End of subcircuit definition.

* Library name: sg13g2_stdcell_hv
* Cell name: sg13g2_hv_a221oi_1
* View name: schematic
.subckt sg13g2_hv_a221oi_1 Y A1 A2 B1 B2 C1 VDD VSS
XP2 Y C1 net3 VDD sg13_hv_pmos w=2.690u l=0.450u ng=1 ad=9.146e-13 as=9.146e-13 pd=6.06e-06 ps=6.06e-06 m=1
XP4 net3 B2 net1 VDD sg13_hv_pmos w=2.690u l=0.450u ng=1 ad=9.146e-13 as=9.146e-13 pd=6.06e-06 ps=6.06e-06 m=1
XP1 net3 B1 net1 VDD sg13_hv_pmos w=2.690u l=0.450u ng=1 ad=9.146e-13 as=9.146e-13 pd=6.06e-06 ps=6.06e-06 m=1
XP3 net1 A2 VDD VDD sg13_hv_pmos w=2.690u l=0.450u ng=1 ad=9.146e-13 as=9.146e-13 pd=6.06e-06 ps=6.06e-06 m=1
XP0 net1 A1 VDD VDD sg13_hv_pmos w=2.690u l=0.450u ng=1 ad=9.146e-13 as=9.146e-13 pd=6.06e-06 ps=6.06e-06 m=1
XN4 Y C1 VSS VSS sg13_hv_nmos w=0.740u l=0.450u ng=1 ad=2.516e-13 as=2.516e-13 pd=2.16e-06 ps=2.16e-06 m=1
XN3 net4 B2 VSS VSS sg13_hv_nmos w=0.740u l=0.450u ng=1 ad=2.516e-13 as=2.516e-13 pd=2.16e-06 ps=2.16e-06 m=1
XN2 Y B1 net4 VSS sg13_hv_nmos w=0.740u l=0.450u ng=1 ad=2.516e-13 as=2.516e-13 pd=2.16e-06 ps=2.16e-06 m=1
XN1 net2 A2 VSS VSS sg13_hv_nmos w=0.740u l=0.450u ng=1 ad=2.516e-13 as=2.516e-13 pd=2.16e-06 ps=2.16e-06 m=1
XN0 Y A1 net2 VSS sg13_hv_nmos w=0.740u l=0.450u ng=1 ad=2.516e-13 as=2.516e-13 pd=2.16e-06 ps=2.16e-06 m=1
.ends
* End of subcircuit definition.

* Library name: sg13g2_stdcell_hv
* Cell name: sg13g2_hv_and2_1
* View name: schematic
.subckt sg13g2_hv_and2_1 X A B VDD VSS
XN0 net4 A net2 VSS sg13_hv_nmos w=0.640u l=0.450u ng=1 ad=2.176e-13 as=2.176e-13 pd=1.96e-06 ps=1.96e-06 m=1
XN2 X net4 VSS VSS sg13_hv_nmos w=0.740u l=0.450u ng=1 ad=2.516e-13 as=2.516e-13 pd=2.16e-06 ps=2.16e-06 m=1
XN1 net2 B VSS VSS sg13_hv_nmos w=0.640u l=0.450u ng=1 ad=2.176e-13 as=2.176e-13 pd=1.96e-06 ps=1.96e-06 m=1
XP0 net4 B VDD VDD sg13_hv_pmos w=2.015u l=0.450u ng=1 ad=6.851e-13 as=6.851e-13 pd=4.71e-06 ps=4.71e-06 m=1
XP2 X net4 VDD VDD sg13_hv_pmos w=2.690u l=0.450u ng=1 ad=9.146e-13 as=9.146e-13 pd=6.06e-06 ps=6.06e-06 m=1
XP1 net4 A VDD VDD sg13_hv_pmos w=2.015u l=0.450u ng=1 ad=6.851e-13 as=6.851e-13 pd=4.71e-06 ps=4.71e-06 m=1
.ends
* End of subcircuit definition.

* Library name: sg13g2_stdcell_hv
* Cell name: sg13g2_hv_and2_2
* View name: schematic
.subckt sg13g2_hv_and2_2 X A B VDD VSS
XN0 net1 A net2 VSS sg13_hv_nmos w=0.640u l=0.450u ng=1 ad=2.176e-13 as=2.176e-13 pd=1.96e-06 ps=1.96e-06 m=1
XN2 X net1 VSS VSS sg13_hv_nmos w=1.480u l=0.450u ng=2 ad=2.812e-13 as=5.032e-13 pd=2.24e-06 ps=4.32e-06 m=1
XN1 net2 B VSS VSS sg13_hv_nmos w=0.640u l=0.450u ng=1 ad=2.176e-13 as=2.176e-13 pd=1.96e-06 ps=1.96e-06 m=1
XP0 net1 B VDD VDD sg13_hv_pmos w=2.015u l=0.450u ng=1 ad=6.851e-13 as=6.851e-13 pd=4.71e-06 ps=4.71e-06 m=1
XP2 X net1 VDD VDD sg13_hv_pmos w=5.380u l=0.450u ng=2 ad=1.0222e-12 as=1.8292e-12 pd=6.14e-06 ps=1.212e-05 m=1
XP1 net1 A VDD VDD sg13_hv_pmos w=2.015u l=0.450u ng=1 ad=6.851e-13 as=6.851e-13 pd=4.71e-06 ps=4.71e-06 m=1
.ends
* End of subcircuit definition.

* Library name: sg13g2_stdcell_hv
* Cell name: sg13g2_hv_and3_1
* View name: schematic
.subckt sg13g2_hv_and3_1 X A B C VDD VSS
XN2 net3 C VSS VSS sg13_hv_nmos w=0.640u l=0.450u ng=1 ad=2.176e-13 as=2.176e-13 pd=1.96e-06 ps=1.96e-06 m=1
XN3 X net2 VSS VSS sg13_hv_nmos w=0.740u l=0.450u ng=1 ad=2.516e-13 as=2.516e-13 pd=2.16e-06 ps=2.16e-06 m=1
XN0 net2 A net1 VSS sg13_hv_nmos w=0.640u l=0.450u ng=1 ad=2.176e-13 as=2.176e-13 pd=1.96e-06 ps=1.96e-06 m=1
XN1 net1 B net3 VSS sg13_hv_nmos w=0.640u l=0.450u ng=1 ad=2.176e-13 as=2.176e-13 pd=1.96e-06 ps=1.96e-06 m=1
XP3 X net2 VDD VDD sg13_hv_pmos w=2.690u l=0.450u ng=1 ad=9.146e-13 as=9.146e-13 pd=6.06e-06 ps=6.06e-06 m=1
XP1 net2 B VDD VDD sg13_hv_pmos w=2.015u l=0.450u ng=1 ad=6.851e-13 as=6.851e-13 pd=4.71e-06 ps=4.71e-06 m=1
XP2 net2 A VDD VDD sg13_hv_pmos w=2.015u l=0.450u ng=1 ad=6.851e-13 as=6.851e-13 pd=4.71e-06 ps=4.71e-06 m=1
XP0 net2 C VDD VDD sg13_hv_pmos w=2.015u l=0.450u ng=1 ad=6.851e-13 as=6.851e-13 pd=4.71e-06 ps=4.71e-06 m=1
.ends
* End of subcircuit definition.

* Library name: sg13g2_stdcell_hv
* Cell name: sg13g2_hv_and3_2
* View name: schematic
.subckt sg13g2_hv_and3_2 X A B C VDD VSS
XN2 net3 C VSS VSS sg13_hv_nmos w=0.640u l=0.450u ng=1 ad=2.176e-13 as=2.176e-13 pd=1.96e-06 ps=1.96e-06 m=1
XN3 X net2 VSS VSS sg13_hv_nmos w=1.480u l=0.450u ng=2 ad=2.812e-13 as=5.032e-13 pd=2.24e-06 ps=4.32e-06 m=1
XN0 net2 A net1 VSS sg13_hv_nmos w=0.640u l=0.450u ng=1 ad=2.176e-13 as=2.176e-13 pd=1.96e-06 ps=1.96e-06 m=1
XN1 net1 B net3 VSS sg13_hv_nmos w=0.640u l=0.450u ng=1 ad=2.176e-13 as=2.176e-13 pd=1.96e-06 ps=1.96e-06 m=1
XP3 X net2 VDD VDD sg13_hv_pmos w=5.380u l=0.450u ng=2 ad=1.0222e-12 as=1.8292e-12 pd=6.14e-06 ps=1.212e-05 m=1
XP1 net2 B VDD VDD sg13_hv_pmos w=2.015u l=0.450u ng=1 ad=6.851e-13 as=6.851e-13 pd=4.71e-06 ps=4.71e-06 m=1
XP2 net2 A VDD VDD sg13_hv_pmos w=2.015u l=0.450u ng=1 ad=6.851e-13 as=6.851e-13 pd=4.71e-06 ps=4.71e-06 m=1
XP0 net2 C VDD VDD sg13_hv_pmos w=2.015u l=0.450u ng=1 ad=6.851e-13 as=6.851e-13 pd=4.71e-06 ps=4.71e-06 m=1
.ends
* End of subcircuit definition.

* Library name: sg13g2_stdcell_hv
* Cell name: sg13g2_hv_and4_1
* View name: schematic
.subckt sg13g2_hv_and4_1 X A B C D VDD VSS
XN3 net17 D VSS VSS sg13_hv_nmos w=0.640u l=0.450u ng=1 ad=2.176e-13 as=2.176e-13 pd=1.96e-06 ps=1.96e-06 m=1
XN2 net16 C net17 VSS sg13_hv_nmos w=0.640u l=0.450u ng=1 ad=2.176e-13 as=2.176e-13 pd=1.96e-06 ps=1.96e-06 m=1
XN1 net15 B net16 VSS sg13_hv_nmos w=0.640u l=0.450u ng=1 ad=2.176e-13 as=2.176e-13 pd=1.96e-06 ps=1.96e-06 m=1
XN0 net1 A net15 VSS sg13_hv_nmos w=0.640u l=0.450u ng=1 ad=2.176e-13 as=2.176e-13 pd=1.96e-06 ps=1.96e-06 m=1
XN4 X net1 VSS VSS sg13_hv_nmos w=0.740u l=0.450u ng=1 ad=2.516e-13 as=2.516e-13 pd=2.16e-06 ps=2.16e-06 m=1
XP3 net1 A VDD VDD sg13_hv_pmos w=2.015u l=0.450u ng=1 ad=6.851e-13 as=6.851e-13 pd=4.71e-06 ps=4.71e-06 m=1
XP4 X net1 VDD VDD sg13_hv_pmos w=2.690u l=0.450u ng=1 ad=9.146e-13 as=9.146e-13 pd=6.06e-06 ps=6.06e-06 m=1
XP0 net1 D VDD VDD sg13_hv_pmos w=2.015u l=0.450u ng=1 ad=6.851e-13 as=6.851e-13 pd=4.71e-06 ps=4.71e-06 m=1
XP1 net1 C VDD VDD sg13_hv_pmos w=2.015u l=0.450u ng=1 ad=6.851e-13 as=6.851e-13 pd=4.71e-06 ps=4.71e-06 m=1
XP2 net1 B VDD VDD sg13_hv_pmos w=2.015u l=0.450u ng=1 ad=6.851e-13 as=6.851e-13 pd=4.71e-06 ps=4.71e-06 m=1
.ends
* End of subcircuit definition.

* Library name: sg13g2_stdcell_hv
* Cell name: sg13g2_hv_and4_2
* View name: schematic
.subckt sg13g2_hv_and4_2 X A B C D VDD VSS
XN3 net17 D VSS VSS sg13_hv_nmos w=0.640u l=0.450u ng=1 ad=2.176e-13 as=2.176e-13 pd=1.96e-06 ps=1.96e-06 m=1
XN2 net16 C net17 VSS sg13_hv_nmos w=0.640u l=0.450u ng=1 ad=2.176e-13 as=2.176e-13 pd=1.96e-06 ps=1.96e-06 m=1
XN1 net15 B net16 VSS sg13_hv_nmos w=0.640u l=0.450u ng=1 ad=2.176e-13 as=2.176e-13 pd=1.96e-06 ps=1.96e-06 m=1
XN0 net1 A net15 VSS sg13_hv_nmos w=0.640u l=0.450u ng=1 ad=2.176e-13 as=2.176e-13 pd=1.96e-06 ps=1.96e-06 m=1
XN4 X net1 VSS VSS sg13_hv_nmos w=1.480u l=0.450u ng=2 ad=2.812e-13 as=5.032e-13 pd=2.24e-06 ps=4.32e-06 m=1
XP3 net1 A VDD VDD sg13_hv_pmos w=2.015u l=0.450u ng=1 ad=6.851e-13 as=6.851e-13 pd=4.71e-06 ps=4.71e-06 m=1
XP4 X net1 VDD VDD sg13_hv_pmos w=5.380u l=0.450u ng=2 ad=1.0222e-12 as=1.8292e-12 pd=6.14e-06 ps=1.212e-05 m=1
XP0 net1 D VDD VDD sg13_hv_pmos w=2.015u l=0.450u ng=1 ad=6.851e-13 as=6.851e-13 pd=4.71e-06 ps=4.71e-06 m=1
XP1 net1 C VDD VDD sg13_hv_pmos w=2.015u l=0.450u ng=1 ad=6.851e-13 as=6.851e-13 pd=4.71e-06 ps=4.71e-06 m=1
XP2 net1 B VDD VDD sg13_hv_pmos w=2.015u l=0.450u ng=1 ad=6.851e-13 as=6.851e-13 pd=4.71e-06 ps=4.71e-06 m=1
.ends
* End of subcircuit definition.

* Library name: sg13g2_stdcell_hv
* Cell name: sg13g2_hv_antennanp
* View name: schematic
.subckt sg13g2_hv_antennanp A VDD VSS
XD1 VSS A dantenna l=780n w=780n m=1
XD0 A VDD dpantenna l=1.34u w=1.05u m=1
.ends
* End of subcircuit definition.

* Library name: sg13g2_stdcell_hv
* Cell name: sg13g2_hv_buf_1
* View name: schematic
.subckt sg13g2_hv_buf_1 X A VDD VSS
XN0 net1 A VSS VSS sg13_hv_nmos w=0.550u l=0.450u ng=1 ad=1.87e-13 as=1.87e-13 pd=1.78e-06 ps=1.78e-06 m=1
XN1 X net1 VSS VSS sg13_hv_nmos w=0.740u l=0.450u ng=1 ad=2.516e-13 as=2.516e-13 pd=2.16e-06 ps=2.16e-06 m=1
XP1 X net1 VDD VDD sg13_hv_pmos w=2.690u l=0.450u ng=1 ad=9.146e-13 as=9.146e-13 pd=6.06e-06 ps=6.06e-06 m=1
XP0 net1 A VDD VDD sg13_hv_pmos w=2.015u l=0.450u ng=1 ad=6.851e-13 as=6.851e-13 pd=4.71e-06 ps=4.71e-06 m=1
.ends
* End of subcircuit definition.

* Library name: sg13g2_stdcell_hv
* Cell name: sg13g2_hv_buf_16
* View name: schematic
.subckt sg13g2_hv_buf_16 X A VDD VSS
XN0 net1 A VSS VSS sg13_hv_nmos w=4.440u l=0.450u ng=6 ad=8.436e-13 as=1.0656e-12 pd=6.72e-06 ps=8.8e-06 m=1
XN1 X net1 VSS VSS sg13_hv_nmos w=11.840u l=0.450u ng=16 ad=2.2496e-12 as=2.4716e-12 pd=1.792e-05 ps=2e-05 m=1
XP1 X net1 VDD VDD sg13_hv_pmos w=43.040u l=0.450u ng=16 ad=8.1776e-12 as=8.9846e-12 pd=4.912e-05 ps=5.51e-05 m=1
XP0 net1 A VDD VDD sg13_hv_pmos w=16.140u l=0.450u ng=6 ad=3.0666e-12 as=3.8736e-12 pd=1.842e-05 ps=2.44e-05 m=1
.ends
* End of subcircuit definition.

* Library name: sg13g2_stdcell_hv
* Cell name: sg13g2_hv_buf_2
* View name: schematic
.subckt sg13g2_hv_buf_2 X A VDD VSS
XN0 net1 A VSS VSS sg13_hv_nmos w=0.640u l=0.450u ng=1 ad=2.176e-13 as=2.176e-13 pd=1.96e-06 ps=1.96e-06 m=1
XN1 X net1 VSS VSS sg13_hv_nmos w=1.480u l=0.450u ng=2 ad=2.812e-13 as=5.032e-13 pd=2.24e-06 ps=4.32e-06 m=1
XP1 X net1 VDD VDD sg13_hv_pmos w=5.380u l=0.450u ng=2 ad=1.0222e-12 as=1.8292e-12 pd=6.14e-06 ps=1.212e-05 m=1
XP0 net1 A VDD VDD sg13_hv_pmos w=2.400u l=0.450u ng=1 ad=8.16e-13 as=8.16e-13 pd=5.48e-06 ps=5.48e-06 m=1
.ends
* End of subcircuit definition.

* Library name: sg13g2_stdcell_hv
* Cell name: sg13g2_hv_buf_4
* View name: schematic
.subckt sg13g2_hv_buf_4 X A VDD VSS
XN0 net1 A VSS VSS sg13_hv_nmos w=0.740u l=0.450u ng=1 ad=2.516e-13 as=2.516e-13 pd=2.16e-06 ps=2.16e-06 m=1
XN1 X net1 VSS VSS sg13_hv_nmos w=2.960u l=0.450u ng=4 ad=5.624e-13 as=7.844e-13 pd=4.48e-06 ps=6.56e-06 m=1
XP1 X net1 VDD VDD sg13_hv_pmos w=10.760u l=0.450u ng=4 ad=2.0444e-12 as=2.8514e-12 pd=1.228e-05 ps=1.826e-05 m=1
XP0 net1 A VDD VDD sg13_hv_pmos w=4.030u l=0.450u ng=2 ad=7.657e-13 as=1.3702e-12 pd=4.79e-06 ps=9.42e-06 m=1
.ends
* End of subcircuit definition.

* Library name: sg13g2_stdcell_hv
* Cell name: sg13g2_hv_buf_8
* View name: schematic
.subckt sg13g2_hv_buf_8 X A VDD VSS
XN0 net1 A VSS VSS sg13_hv_nmos w=2.220u l=0.450u ng=3 ad=5.328e-13 as=5.328e-13 pd=4.4e-06 ps=4.4e-06 m=1
XN1 X net1 VSS VSS sg13_hv_nmos w=5.920u l=0.450u ng=8 ad=1.1248e-12 as=1.3468e-12 pd=8.96e-06 ps=1.104e-05 m=1
XP1 X net1 VDD VDD sg13_hv_pmos w=21.520u l=0.450u ng=8 ad=4.0888e-12 as=4.8958e-12 pd=2.456e-05 ps=3.054e-05 m=1
XP0 net1 A VDD VDD sg13_hv_pmos w=8.070u l=0.450u ng=3 ad=1.9368e-12 as=1.9368e-12 pd=1.22e-05 ps=1.22e-05 m=1
.ends
* End of subcircuit definition.

* Library name: sg13g2_stdcell_hv
* Cell name: sg13g2_hv_decap_4
* View name: schematic
.subckt sg13g2_hv_decap_4 VDD VSS
XN0 VSS VDD VSS VSS sg13_hv_nmos w=0.420u l=1.000u ng=1 ad=1.428e-13 as=1.428e-13 pd=1.52e-06 ps=1.52e-06 m=1
XP0 VDD VSS VDD VDD sg13_hv_pmos w=2.400u l=1.000u ng=1 ad=8.16e-13 as=8.16e-13 pd=5.48e-06 ps=5.48e-06 m=1
.ends
* End of subcircuit definition.

* Library name: sg13g2_stdcell_hv
* Cell name: sg13g2_hv_decap_8
* View name: schematic
.subckt sg13g2_hv_decap_8 VDD VSS
XN0 VSS VDD VSS VSS sg13_hv_nmos w=0.840u l=1.000u ng=2 ad=1.596e-13 as=2.856e-13 pd=1.6e-06 ps=3.04e-06 m=1
XP0 VDD VSS VDD VDD sg13_hv_pmos w=4.800u l=1.000u ng=2 ad=9.12e-13 as=1.632e-12 pd=5.56e-06 ps=1.096e-05 m=1
.ends
* End of subcircuit definition.

* Library name: sg13g2_stdcell_hv
* Cell name: sg13g2_hv_dfrbp_1
* View name: schematic
.subckt sg13g2_hv_dfrbp_1 Q Q_N CLK D RESET_B VDD VSS
XN11 net12 net2 VSS VSS sg13_hv_nmos w=0.420u l=0.450u ng=1 ad=1.428e-13 as=1.428e-13 pd=1.52e-06 ps=1.52e-06 m=1
XN10 net5 clkneg net12 VSS sg13_hv_nmos w=0.420u l=0.450u ng=1 ad=1.428e-13 as=1.428e-13 pd=1.52e-06 ps=1.52e-06 m=1
XN12 net2 net5 net11 VSS sg13_hv_nmos w=0.420u l=0.450u ng=1 ad=1.428e-13 as=1.428e-13 pd=1.52e-06 ps=1.52e-06 m=1
XN13 net11 RESET_B VSS VSS sg13_hv_nmos w=0.420u l=0.450u ng=1 ad=1.428e-13 as=1.428e-13 pd=1.52e-06 ps=1.52e-06 m=1
XN14 Q_N net5 VSS VSS sg13_hv_nmos w=0.740u l=0.450u ng=1 ad=2.516e-13 as=2.516e-13 pd=2.16e-06 ps=2.16e-06 m=1
XN0 Db D net10 VSS sg13_hv_nmos w=0.420u l=0.450u ng=1 ad=1.428e-13 as=1.428e-13 pd=1.52e-06 ps=1.52e-06 m=1
XN1 net10 RESET_B VSS VSS sg13_hv_nmos w=0.420u l=0.450u ng=1 ad=1.428e-13 as=1.428e-13 pd=1.52e-06 ps=1.52e-06 m=1
XN4 Db clkneg net6 VSS sg13_hv_nmos w=0.420u l=0.450u ng=1 ad=1.428e-13 as=1.428e-13 pd=1.52e-06 ps=1.52e-06 m=1
XN5 net6 clkpos net9 VSS sg13_hv_nmos w=0.420u l=0.450u ng=1 ad=1.428e-13 as=1.428e-13 pd=1.52e-06 ps=1.52e-06 m=1
XN6 net9 net4 net8 VSS sg13_hv_nmos w=0.420u l=0.450u ng=1 ad=1.428e-13 as=1.428e-13 pd=1.52e-06 ps=1.52e-06 m=1
XN7 net8 RESET_B VSS VSS sg13_hv_nmos w=0.420u l=0.450u ng=1 ad=1.428e-13 as=1.428e-13 pd=1.52e-06 ps=1.52e-06 m=1
XN8 net4 net6 VSS VSS sg13_hv_nmos w=0.740u l=0.450u ng=1 ad=2.516e-13 as=2.516e-13 pd=2.16e-06 ps=2.16e-06 m=1
XN2 clkneg CLK VSS VSS sg13_hv_nmos w=0.740u l=0.450u ng=1 ad=2.516e-13 as=2.516e-13 pd=2.16e-06 ps=2.16e-06 m=1
XN9 net4 clkpos net5 VSS sg13_hv_nmos w=0.740u l=0.450u ng=1 ad=2.516e-13 as=2.516e-13 pd=2.16e-06 ps=2.16e-06 m=1
XN3 clkpos clkneg VSS VSS sg13_hv_nmos w=0.740u l=0.450u ng=1 ad=2.516e-13 as=2.516e-13 pd=2.16e-06 ps=2.16e-06 m=1
XN16 Q net1 VSS VSS sg13_hv_nmos w=0.740u l=0.450u ng=1 ad=2.516e-13 as=2.516e-13 pd=2.16e-06 ps=2.16e-06 m=1
XN15 net1 net5 VSS VSS sg13_hv_nmos w=0.740u l=0.450u ng=1 ad=2.516e-13 as=2.516e-13 pd=2.16e-06 ps=2.16e-06 m=1
XP11 net5 clkpos net3 VDD sg13_hv_pmos w=1.010u l=0.450u ng=1 ad=3.434e-13 as=3.434e-13 pd=2.7e-06 ps=2.7e-06 m=1
XP12 net2 net5 VDD VDD sg13_hv_pmos w=1.010u l=0.450u ng=1 ad=3.434e-13 as=3.434e-13 pd=2.7e-06 ps=2.7e-06 m=1
XP13 net2 RESET_B VDD VDD sg13_hv_pmos w=1.010u l=0.450u ng=1 ad=3.434e-13 as=3.434e-13 pd=2.7e-06 ps=2.7e-06 m=1
XP14 Q_N net5 VDD VDD sg13_hv_pmos w=2.690u l=0.450u ng=1 ad=9.146e-13 as=9.146e-13 pd=6.06e-06 ps=6.06e-06 m=1
XP4 Db clkpos net6 VDD sg13_hv_pmos w=1.010u l=0.450u ng=1 ad=3.434e-13 as=3.434e-13 pd=2.7e-06 ps=2.7e-06 m=1
XP0 Db RESET_B VDD VDD sg13_hv_pmos w=1.010u l=0.450u ng=1 ad=3.434e-13 as=3.434e-13 pd=2.7e-06 ps=2.7e-06 m=1
XP1 Db D VDD VDD sg13_hv_pmos w=1.010u l=0.450u ng=1 ad=3.434e-13 as=3.434e-13 pd=2.7e-06 ps=2.7e-06 m=1
XP5 net7 net4 VDD VDD sg13_hv_pmos w=1.010u l=0.450u ng=1 ad=3.434e-13 as=3.434e-13 pd=2.7e-06 ps=2.7e-06 m=1
XP6 net6 clkneg net7 VDD sg13_hv_pmos w=1.010u l=0.450u ng=1 ad=3.434e-13 as=3.434e-13 pd=2.7e-06 ps=2.7e-06 m=1
XP7 net6 RESET_B VDD VDD sg13_hv_pmos w=1.010u l=0.450u ng=1 ad=3.434e-13 as=3.434e-13 pd=2.7e-06 ps=2.7e-06 m=1
XP2 clkneg CLK VDD VDD sg13_hv_pmos w=2.690u l=0.450u ng=1 ad=9.146e-13 as=9.146e-13 pd=6.06e-06 ps=6.06e-06 m=1
XP3 clkpos clkneg VDD VDD sg13_hv_pmos w=2.690u l=0.450u ng=1 ad=9.146e-13 as=9.146e-13 pd=6.06e-06 ps=6.06e-06 m=1
XP8 net4 net6 VDD VDD sg13_hv_pmos w=2.400u l=0.450u ng=1 ad=8.16e-13 as=8.16e-13 pd=5.48e-06 ps=5.48e-06 m=1
XP9 net4 clkneg net5 VDD sg13_hv_pmos w=2.400u l=0.450u ng=1 ad=8.16e-13 as=8.16e-13 pd=5.48e-06 ps=5.48e-06 m=1
XP16 Q net1 VDD VDD sg13_hv_pmos w=2.690u l=0.450u ng=1 ad=9.146e-13 as=9.146e-13 pd=6.06e-06 ps=6.06e-06 m=1
XP10 net3 net2 VDD VDD sg13_hv_pmos w=1.010u l=0.450u ng=1 ad=3.434e-13 as=3.434e-13 pd=2.7e-06 ps=2.7e-06 m=1
XP15 net1 net5 VDD VDD sg13_hv_pmos w=2.690u l=0.450u ng=1 ad=9.146e-13 as=9.146e-13 pd=6.06e-06 ps=6.06e-06 m=1
.ends
* End of subcircuit definition.

* Library name: sg13g2_stdcell_hv
* Cell name: sg13g2_hv_dfrbp_2
* View name: schematic
.subckt sg13g2_hv_dfrbp_2 Q Q_N CLK D RESET_B VDD VSS
XN11 net12 net2 VSS VSS sg13_hv_nmos w=0.420u l=0.450u ng=1 ad=1.428e-13 as=1.428e-13 pd=1.52e-06 ps=1.52e-06 m=1
XN10 net5 clkneg net12 VSS sg13_hv_nmos w=0.420u l=0.450u ng=1 ad=1.428e-13 as=1.428e-13 pd=1.52e-06 ps=1.52e-06 m=1
XN12 net2 net5 net11 VSS sg13_hv_nmos w=0.420u l=0.450u ng=1 ad=1.428e-13 as=1.428e-13 pd=1.52e-06 ps=1.52e-06 m=1
XN13 net11 RESET_B VSS VSS sg13_hv_nmos w=0.420u l=0.450u ng=1 ad=1.428e-13 as=1.428e-13 pd=1.52e-06 ps=1.52e-06 m=1
XN14 Q_N net5 VSS VSS sg13_hv_nmos w=1.480u l=0.450u ng=2 ad=2.812e-13 as=5.032e-13 pd=2.24e-06 ps=4.32e-06 m=1
XN0 Db D net10 VSS sg13_hv_nmos w=0.420u l=0.450u ng=1 ad=1.428e-13 as=1.428e-13 pd=1.52e-06 ps=1.52e-06 m=1
XN1 net10 RESET_B VSS VSS sg13_hv_nmos w=0.420u l=0.450u ng=1 ad=1.428e-13 as=1.428e-13 pd=1.52e-06 ps=1.52e-06 m=1
XN4 Db clkneg net6 VSS sg13_hv_nmos w=0.420u l=0.450u ng=1 ad=1.428e-13 as=1.428e-13 pd=1.52e-06 ps=1.52e-06 m=1
XN5 net6 clkpos net9 VSS sg13_hv_nmos w=0.420u l=0.450u ng=1 ad=1.428e-13 as=1.428e-13 pd=1.52e-06 ps=1.52e-06 m=1
XN6 net9 net4 net8 VSS sg13_hv_nmos w=0.420u l=0.450u ng=1 ad=1.428e-13 as=1.428e-13 pd=1.52e-06 ps=1.52e-06 m=1
XN7 net8 RESET_B VSS VSS sg13_hv_nmos w=0.420u l=0.450u ng=1 ad=1.428e-13 as=1.428e-13 pd=1.52e-06 ps=1.52e-06 m=1
XN8 net4 net6 VSS VSS sg13_hv_nmos w=0.740u l=0.450u ng=1 ad=2.516e-13 as=2.516e-13 pd=2.16e-06 ps=2.16e-06 m=1
XN2 clkneg CLK VSS VSS sg13_hv_nmos w=0.740u l=0.450u ng=1 ad=2.516e-13 as=2.516e-13 pd=2.16e-06 ps=2.16e-06 m=1
XN9 net4 clkpos net5 VSS sg13_hv_nmos w=0.740u l=0.450u ng=1 ad=2.516e-13 as=2.516e-13 pd=2.16e-06 ps=2.16e-06 m=1
XN3 clkpos clkneg VSS VSS sg13_hv_nmos w=0.740u l=0.450u ng=1 ad=2.516e-13 as=2.516e-13 pd=2.16e-06 ps=2.16e-06 m=1
XN16 Q net1 VSS VSS sg13_hv_nmos w=1.480u l=0.450u ng=2 ad=2.812e-13 as=5.032e-13 pd=2.24e-06 ps=4.32e-06 m=1
XN15 net1 net5 VSS VSS sg13_hv_nmos w=0.640u l=0.450u ng=1 ad=2.176e-13 as=2.176e-13 pd=1.96e-06 ps=1.96e-06 m=1
XP11 net5 clkpos net3 VDD sg13_hv_pmos w=1.010u l=0.450u ng=1 ad=3.434e-13 as=3.434e-13 pd=2.7e-06 ps=2.7e-06 m=1
XP12 net2 net5 VDD VDD sg13_hv_pmos w=1.010u l=0.450u ng=1 ad=3.434e-13 as=3.434e-13 pd=2.7e-06 ps=2.7e-06 m=1
XP13 net2 RESET_B VDD VDD sg13_hv_pmos w=1.010u l=0.450u ng=1 ad=3.434e-13 as=3.434e-13 pd=2.7e-06 ps=2.7e-06 m=1
XP14 Q_N net5 VDD VDD sg13_hv_pmos w=5.380u l=0.450u ng=2 ad=1.0222e-12 as=1.8292e-12 pd=6.14e-06 ps=1.212e-05 m=1
XP4 Db clkpos net6 VDD sg13_hv_pmos w=1.010u l=0.450u ng=1 ad=3.434e-13 as=3.434e-13 pd=2.7e-06 ps=2.7e-06 m=1
XP0 Db RESET_B VDD VDD sg13_hv_pmos w=1.010u l=0.450u ng=1 ad=3.434e-13 as=3.434e-13 pd=2.7e-06 ps=2.7e-06 m=1
XP1 Db D VDD VDD sg13_hv_pmos w=1.010u l=0.450u ng=1 ad=3.434e-13 as=3.434e-13 pd=2.7e-06 ps=2.7e-06 m=1
XP5 net7 net4 VDD VDD sg13_hv_pmos w=1.010u l=0.450u ng=1 ad=3.434e-13 as=3.434e-13 pd=2.7e-06 ps=2.7e-06 m=1
XP6 net6 clkneg net7 VDD sg13_hv_pmos w=1.010u l=0.450u ng=1 ad=3.434e-13 as=3.434e-13 pd=2.7e-06 ps=2.7e-06 m=1
XP7 net6 RESET_B VDD VDD sg13_hv_pmos w=1.010u l=0.450u ng=1 ad=3.434e-13 as=3.434e-13 pd=2.7e-06 ps=2.7e-06 m=1
XP2 clkneg CLK VDD VDD sg13_hv_pmos w=2.690u l=0.450u ng=1 ad=9.146e-13 as=9.146e-13 pd=6.06e-06 ps=6.06e-06 m=1
XP3 clkpos clkneg VDD VDD sg13_hv_pmos w=2.690u l=0.450u ng=1 ad=9.146e-13 as=9.146e-13 pd=6.06e-06 ps=6.06e-06 m=1
XP8 net4 net6 VDD VDD sg13_hv_pmos w=2.400u l=0.450u ng=1 ad=8.16e-13 as=8.16e-13 pd=5.48e-06 ps=5.48e-06 m=1
XP9 net4 clkneg net5 VDD sg13_hv_pmos w=2.400u l=0.450u ng=1 ad=8.16e-13 as=8.16e-13 pd=5.48e-06 ps=5.48e-06 m=1
XP16 Q net1 VDD VDD sg13_hv_pmos w=5.380u l=0.450u ng=2 ad=1.0222e-12 as=1.8292e-12 pd=6.14e-06 ps=1.212e-05 m=1
XP10 net3 net2 VDD VDD sg13_hv_pmos w=1.010u l=0.450u ng=1 ad=3.434e-13 as=3.434e-13 pd=2.7e-06 ps=2.7e-06 m=1
XP15 net1 net5 VDD VDD sg13_hv_pmos w=2.400u l=0.450u ng=1 ad=8.16e-13 as=8.16e-13 pd=5.48e-06 ps=5.48e-06 m=1
.ends
* End of subcircuit definition.

* Library name: sg13g2_stdcell_hv
* Cell name: sg13g2_hv_dlhq_1
* View name: schematic
.subckt sg13g2_hv_dlhq_1 Q D GATE VDD VSS
XP8 Q qint_b VDD VDD sg13_hv_pmos w=2.690u l=0.450u ng=1 ad=9.146e-13 as=9.146e-13 pd=6.06e-06 ps=6.06e-06 m=1
XP6 qint GATE_BB net8 VDD sg13_hv_pmos w=1.010u l=0.450u ng=1 ad=3.434e-13 as=3.434e-13 pd=2.7e-06 ps=2.7e-06 m=1
XP7 qint_b qint VDD VDD sg13_hv_pmos w=2.690u l=0.450u ng=1 ad=9.146e-13 as=9.146e-13 pd=6.06e-06 ps=6.06e-06 m=1
XP2 Db D VDD VDD sg13_hv_pmos w=2.015u l=0.450u ng=1 ad=6.851e-13 as=6.851e-13 pd=4.71e-06 ps=4.71e-06 m=1
XP0 GATE_B GATE VDD VDD sg13_hv_pmos w=2.015u l=0.450u ng=1 ad=6.851e-13 as=6.851e-13 pd=4.71e-06 ps=4.71e-06 m=1
XP1 GATE_BB GATE_B VDD VDD sg13_hv_pmos w=2.015u l=0.450u ng=1 ad=6.851e-13 as=6.851e-13 pd=4.71e-06 ps=4.71e-06 m=1
XP5 net8 qint_b VDD VDD sg13_hv_pmos w=1.010u l=0.450u ng=1 ad=3.434e-13 as=3.434e-13 pd=2.7e-06 ps=2.7e-06 m=1
XP4 net4 GATE_B qint VDD sg13_hv_pmos w=2.400u l=0.450u ng=1 ad=8.16e-13 as=8.16e-13 pd=5.48e-06 ps=5.48e-06 m=1
XP3 net4 Db VDD VDD sg13_hv_pmos w=2.400u l=0.450u ng=1 ad=8.16e-13 as=8.16e-13 pd=5.48e-06 ps=5.48e-06 m=1
XN0 GATE_B GATE VSS VSS sg13_hv_nmos w=0.740u l=0.450u ng=1 ad=2.516e-13 as=2.516e-13 pd=2.16e-06 ps=2.16e-06 m=1
XN1 GATE_BB GATE_B VSS VSS sg13_hv_nmos w=0.740u l=0.450u ng=1 ad=2.516e-13 as=2.516e-13 pd=2.16e-06 ps=2.16e-06 m=1
XN5 qint GATE_B net9 VSS sg13_hv_nmos w=0.420u l=0.450u ng=1 ad=1.428e-13 as=1.428e-13 pd=1.52e-06 ps=1.52e-06 m=1
XN8 Q qint_b VSS VSS sg13_hv_nmos w=0.740u l=0.450u ng=1 ad=2.516e-13 as=2.516e-13 pd=2.16e-06 ps=2.16e-06 m=1
XN4 net7 Db VSS VSS sg13_hv_nmos w=0.740u l=0.450u ng=1 ad=2.516e-13 as=2.516e-13 pd=2.16e-06 ps=2.16e-06 m=1
XN6 net9 qint_b VSS VSS sg13_hv_nmos w=0.420u l=0.450u ng=1 ad=1.428e-13 as=1.428e-13 pd=1.52e-06 ps=1.52e-06 m=1
XN7 qint_b qint VSS VSS sg13_hv_nmos w=0.740u l=0.450u ng=1 ad=2.516e-13 as=2.516e-13 pd=2.16e-06 ps=2.16e-06 m=1
XN3 qint GATE_BB net7 VSS sg13_hv_nmos w=0.740u l=0.450u ng=1 ad=2.516e-13 as=2.516e-13 pd=2.16e-06 ps=2.16e-06 m=1
XN2 Db D VSS VSS sg13_hv_nmos w=0.550u l=0.450u ng=1 ad=1.87e-13 as=1.87e-13 pd=1.78e-06 ps=1.78e-06 m=1
.ends
* End of subcircuit definition.

* Library name: sg13g2_stdcell_hv
* Cell name: sg13g2_hv_dlhr_1
* View name: schematic
.subckt sg13g2_hv_dlhr_1 Q Q_N D GATE RESET_B VDD VSS
XP8 qint_b RESET_B VDD VDD sg13_hv_pmos w=2.690u l=0.450u ng=1 ad=9.146e-13 as=9.146e-13 pd=6.06e-06 ps=6.06e-06 m=1
XP9 Q qint_b VDD VDD sg13_hv_pmos w=2.690u l=0.450u ng=1 ad=9.146e-13 as=9.146e-13 pd=6.06e-06 ps=6.06e-06 m=1
XP6 qint GATE_BB net11 VDD sg13_hv_pmos w=1.010u l=0.450u ng=1 ad=3.434e-13 as=3.434e-13 pd=2.7e-06 ps=2.7e-06 m=1
XP5 net11 qint_b VDD VDD sg13_hv_pmos w=1.010u l=0.450u ng=1 ad=3.434e-13 as=3.434e-13 pd=2.7e-06 ps=2.7e-06 m=1
XP4 qint GATE_B net2 VDD sg13_hv_pmos w=2.400u l=0.450u ng=1 ad=8.16e-13 as=8.16e-13 pd=5.48e-06 ps=5.48e-06 m=1
XP3 net2 Db VDD VDD sg13_hv_pmos w=2.400u l=0.450u ng=1 ad=8.16e-13 as=8.16e-13 pd=5.48e-06 ps=5.48e-06 m=1
XP2 Db D VDD VDD sg13_hv_pmos w=2.015u l=0.450u ng=1 ad=6.851e-13 as=6.851e-13 pd=4.71e-06 ps=4.71e-06 m=1
XP0 GATE_B GATE VDD VDD sg13_hv_pmos w=2.015u l=0.450u ng=1 ad=6.851e-13 as=6.851e-13 pd=4.71e-06 ps=4.71e-06 m=1
XP11 Q_N qintn_b VDD VDD sg13_hv_pmos w=2.690u l=0.450u ng=1 ad=9.146e-13 as=9.146e-13 pd=6.06e-06 ps=6.06e-06 m=1
XP7 qint_b qint VDD VDD sg13_hv_pmos w=2.690u l=0.450u ng=1 ad=9.146e-13 as=9.146e-13 pd=6.06e-06 ps=6.06e-06 m=1
XP1 GATE_BB GATE_B VDD VDD sg13_hv_pmos w=2.015u l=0.450u ng=1 ad=6.851e-13 as=6.851e-13 pd=4.71e-06 ps=4.71e-06 m=1
XP10 qintn_b qint_b VDD VDD sg13_hv_pmos w=2.015u l=0.450u ng=1 ad=6.851e-13 as=6.851e-13 pd=4.71e-06 ps=4.71e-06 m=1
XN7 qint_b qint net9 VSS sg13_hv_nmos w=0.740u l=0.450u ng=1 ad=2.516e-13 as=2.516e-13 pd=2.16e-06 ps=2.16e-06 m=1
XN8 net9 RESET_B VSS VSS sg13_hv_nmos w=0.740u l=0.450u ng=1 ad=2.516e-13 as=2.516e-13 pd=2.16e-06 ps=2.16e-06 m=1
XN5 qint GATE_B net7 VSS sg13_hv_nmos w=0.420u l=0.450u ng=1 ad=1.428e-13 as=1.428e-13 pd=1.52e-06 ps=1.52e-06 m=1
XN6 net7 qint_b VSS VSS sg13_hv_nmos w=0.420u l=0.450u ng=1 ad=1.428e-13 as=1.428e-13 pd=1.52e-06 ps=1.52e-06 m=1
XN9 Q qint_b VSS VSS sg13_hv_nmos w=0.740u l=0.450u ng=1 ad=2.516e-13 as=2.516e-13 pd=2.16e-06 ps=2.16e-06 m=1
XN3 qint GATE_BB net1 VSS sg13_hv_nmos w=0.640u l=0.450u ng=1 ad=2.176e-13 as=2.176e-13 pd=1.96e-06 ps=1.96e-06 m=1
XN4 net1 Db VSS VSS sg13_hv_nmos w=0.640u l=0.450u ng=1 ad=2.176e-13 as=2.176e-13 pd=1.96e-06 ps=1.96e-06 m=1
XN2 Db D VSS VSS sg13_hv_nmos w=0.550u l=0.450u ng=1 ad=1.87e-13 as=1.87e-13 pd=1.78e-06 ps=1.78e-06 m=1
XN0 GATE_B GATE VSS VSS sg13_hv_nmos w=0.740u l=0.450u ng=1 ad=2.516e-13 as=2.516e-13 pd=2.16e-06 ps=2.16e-06 m=1
XN11 Q_N qintn_b VSS VSS sg13_hv_nmos w=0.740u l=0.450u ng=1 ad=2.516e-13 as=2.516e-13 pd=2.16e-06 ps=2.16e-06 m=1
XN1 GATE_BB GATE_B VSS VSS sg13_hv_nmos w=0.740u l=0.450u ng=1 ad=2.516e-13 as=2.516e-13 pd=2.16e-06 ps=2.16e-06 m=1
XN10 qintn_b qint_b VSS VSS sg13_hv_nmos w=0.550u l=0.450u ng=1 ad=1.87e-13 as=1.87e-13 pd=1.78e-06 ps=1.78e-06 m=1
.ends
* End of subcircuit definition.

* Library name: sg13g2_stdcell_hv
* Cell name: sg13g2_hv_dlhrq_1
* View name: schematic
.subckt sg13g2_hv_dlhrq_1 Q D GATE RESET_B VDD VSS
XN8 net116 RESET_B VSS VSS sg13_hv_nmos w=0.740u l=0.450u ng=1 ad=2.516e-13 as=2.516e-13 pd=2.16e-06 ps=2.16e-06 m=1
XN9 Q qint_b VSS VSS sg13_hv_nmos w=0.740u l=0.450u ng=1 ad=2.516e-13 as=2.516e-13 pd=2.16e-06 ps=2.16e-06 m=1
XN1 GATE_BB GATE_B VSS VSS sg13_hv_nmos w=0.740u l=0.450u ng=1 ad=2.516e-13 as=2.516e-13 pd=2.16e-06 ps=2.16e-06 m=1
XN5 qint GATE_B net89 VSS sg13_hv_nmos w=0.420u l=0.450u ng=1 ad=1.428e-13 as=1.428e-13 pd=1.52e-06 ps=1.52e-06 m=1
XN7 qint_b qint net116 VSS sg13_hv_nmos w=0.740u l=0.450u ng=1 ad=2.516e-13 as=2.516e-13 pd=2.16e-06 ps=2.16e-06 m=1
XN2 Db D VSS VSS sg13_hv_nmos w=0.550u l=0.450u ng=1 ad=1.87e-13 as=1.87e-13 pd=1.78e-06 ps=1.78e-06 m=1
XN4 net61 Db VSS VSS sg13_hv_nmos w=0.640u l=0.450u ng=1 ad=2.176e-13 as=2.176e-13 pd=1.96e-06 ps=1.96e-06 m=1
XN3 qint GATE_BB net61 VSS sg13_hv_nmos w=0.640u l=0.450u ng=1 ad=2.176e-13 as=2.176e-13 pd=1.96e-06 ps=1.96e-06 m=1
XN6 net89 qint_b VSS VSS sg13_hv_nmos w=0.420u l=0.450u ng=1 ad=1.428e-13 as=1.428e-13 pd=1.52e-06 ps=1.52e-06 m=1
XN0 GATE_B GATE VSS VSS sg13_hv_nmos w=0.740u l=0.450u ng=1 ad=2.516e-13 as=2.516e-13 pd=2.16e-06 ps=2.16e-06 m=1
XP3 net60 Db VDD VDD sg13_hv_pmos w=2.400u l=0.450u ng=1 ad=8.16e-13 as=8.16e-13 pd=5.48e-06 ps=5.48e-06 m=1
XP8 qint_b RESET_B VDD VDD sg13_hv_pmos w=2.400u l=0.450u ng=1 ad=8.16e-13 as=8.16e-13 pd=5.48e-06 ps=5.48e-06 m=1
XP6 qint GATE_BB net92 VDD sg13_hv_pmos w=1.010u l=0.450u ng=1 ad=3.434e-13 as=3.434e-13 pd=2.7e-06 ps=2.7e-06 m=1
XP9 Q qint_b VDD VDD sg13_hv_pmos w=2.690u l=0.450u ng=1 ad=9.146e-13 as=9.146e-13 pd=6.06e-06 ps=6.06e-06 m=1
XP5 net92 qint_b VDD VDD sg13_hv_pmos w=1.010u l=0.450u ng=1 ad=3.434e-13 as=3.434e-13 pd=2.7e-06 ps=2.7e-06 m=1
XP0 GATE_B GATE VDD VDD sg13_hv_pmos w=2.015u l=0.450u ng=1 ad=6.851e-13 as=6.851e-13 pd=4.71e-06 ps=4.71e-06 m=1
XP2 Db D VDD VDD sg13_hv_pmos w=2.015u l=0.450u ng=1 ad=6.851e-13 as=6.851e-13 pd=4.71e-06 ps=4.71e-06 m=1
XP4 qint GATE_B net60 VDD sg13_hv_pmos w=2.400u l=0.450u ng=1 ad=8.16e-13 as=8.16e-13 pd=5.48e-06 ps=5.48e-06 m=1
XP1 GATE_BB GATE_B VDD VDD sg13_hv_pmos w=2.015u l=0.450u ng=1 ad=6.851e-13 as=6.851e-13 pd=4.71e-06 ps=4.71e-06 m=1
XP7 qint_b qint VDD VDD sg13_hv_pmos w=2.400u l=0.450u ng=1 ad=8.16e-13 as=8.16e-13 pd=5.48e-06 ps=5.48e-06 m=1
.ends
* End of subcircuit definition.

* Library name: sg13g2_stdcell_hv
* Cell name: sg13g2_hv_dllr_1
* View name: schematic
.subckt sg13g2_hv_dllr_1 Q Q_N D GATE_N RESET_B VDD VSS
XN2 Db D VSS VSS sg13_hv_nmos w=0.550u l=0.450u ng=1 ad=1.87e-13 as=1.87e-13 pd=1.78e-06 ps=1.78e-06 m=1
XN0 gnb GATE_N VSS VSS sg13_hv_nmos w=0.740u l=0.450u ng=1 ad=2.516e-13 as=2.516e-13 pd=2.16e-06 ps=2.16e-06 m=1
XN1 gnbb gnb VSS VSS sg13_hv_nmos w=0.740u l=0.450u ng=1 ad=2.516e-13 as=2.516e-13 pd=2.16e-06 ps=2.16e-06 m=1
XN6 net89 qint_b VSS VSS sg13_hv_nmos w=0.420u l=0.450u ng=1 ad=1.428e-13 as=1.428e-13 pd=1.52e-06 ps=1.52e-06 m=1
XN7 qint_b qint net116 VSS sg13_hv_nmos w=0.740u l=0.450u ng=1 ad=2.516e-13 as=2.516e-13 pd=2.16e-06 ps=2.16e-06 m=1
XN8 net116 RESET_B VSS VSS sg13_hv_nmos w=0.740u l=0.450u ng=1 ad=2.516e-13 as=2.516e-13 pd=2.16e-06 ps=2.16e-06 m=1
XN5 qint gnbb net89 VSS sg13_hv_nmos w=0.420u l=0.450u ng=1 ad=1.428e-13 as=1.428e-13 pd=1.52e-06 ps=1.52e-06 m=1
XN11 Q_N qintn_b VSS VSS sg13_hv_nmos w=0.740u l=0.450u ng=1 ad=2.516e-13 as=2.516e-13 pd=2.16e-06 ps=2.16e-06 m=1
XN3 qint gnb net61 VSS sg13_hv_nmos w=0.640u l=0.450u ng=1 ad=2.176e-13 as=2.176e-13 pd=1.96e-06 ps=1.96e-06 m=1
XN10 qintn_b qint_b VSS VSS sg13_hv_nmos w=0.550u l=0.450u ng=1 ad=1.87e-13 as=1.87e-13 pd=1.78e-06 ps=1.78e-06 m=1
XN4 net61 Db VSS VSS sg13_hv_nmos w=0.640u l=0.450u ng=1 ad=2.176e-13 as=2.176e-13 pd=1.96e-06 ps=1.96e-06 m=1
XN9 Q qint_b VSS VSS sg13_hv_nmos w=0.740u l=0.450u ng=1 ad=2.516e-13 as=2.516e-13 pd=2.16e-06 ps=2.16e-06 m=1
XP1 gnbb gnb VDD VDD sg13_hv_pmos w=2.015u l=0.450u ng=1 ad=6.851e-13 as=6.851e-13 pd=4.71e-06 ps=4.71e-06 m=1
XP4 qint gnbb net60 VDD sg13_hv_pmos w=2.400u l=0.450u ng=1 ad=8.16e-13 as=8.16e-13 pd=5.48e-06 ps=5.48e-06 m=1
XP10 qintn_b qint_b VDD VDD sg13_hv_pmos w=2.015u l=0.450u ng=1 ad=6.851e-13 as=6.851e-13 pd=4.71e-06 ps=4.71e-06 m=1
XP11 Q_N qintn_b VDD VDD sg13_hv_pmos w=2.690u l=0.450u ng=1 ad=9.146e-13 as=9.146e-13 pd=6.06e-06 ps=6.06e-06 m=1
XP3 net60 Db VDD VDD sg13_hv_pmos w=2.400u l=0.450u ng=1 ad=8.16e-13 as=8.16e-13 pd=5.48e-06 ps=5.48e-06 m=1
XP5 net92 qint_b VDD VDD sg13_hv_pmos w=1.010u l=0.450u ng=1 ad=3.434e-13 as=3.434e-13 pd=2.7e-06 ps=2.7e-06 m=1
XP8 qint_b RESET_B VDD VDD sg13_hv_pmos w=2.690u l=0.450u ng=1 ad=9.146e-13 as=9.146e-13 pd=6.06e-06 ps=6.06e-06 m=1
XP2 Db D VDD VDD sg13_hv_pmos w=2.015u l=0.450u ng=1 ad=6.851e-13 as=6.851e-13 pd=4.71e-06 ps=4.71e-06 m=1
XP0 gnb GATE_N VDD VDD sg13_hv_pmos w=2.015u l=0.450u ng=1 ad=6.851e-13 as=6.851e-13 pd=4.71e-06 ps=4.71e-06 m=1
XP9 Q qint_b VDD VDD sg13_hv_pmos w=2.690u l=0.450u ng=1 ad=9.146e-13 as=9.146e-13 pd=6.06e-06 ps=6.06e-06 m=1
XP6 qint gnb net92 VDD sg13_hv_pmos w=1.010u l=0.450u ng=1 ad=3.434e-13 as=3.434e-13 pd=2.7e-06 ps=2.7e-06 m=1
XP7 qint_b qint VDD VDD sg13_hv_pmos w=2.690u l=0.450u ng=1 ad=9.146e-13 as=9.146e-13 pd=6.06e-06 ps=6.06e-06 m=1
.ends
* End of subcircuit definition.

* Library name: sg13g2_stdcell_hv
* Cell name: sg13g2_hv_dllrq_1
* View name: schematic
.subckt sg13g2_hv_dllrq_1 Q D GATE_N RESET_B VDD VSS
XN5 qint gnbb net89 VSS sg13_hv_nmos w=0.420u l=0.450u ng=1 ad=1.428e-13 as=1.428e-13 pd=1.52e-06 ps=1.52e-06 m=1
XN3 qint gnb net61 VSS sg13_hv_nmos w=0.640u l=0.450u ng=1 ad=2.176e-13 as=2.176e-13 pd=1.96e-06 ps=1.96e-06 m=1
XN8 net116 RESET_B VSS VSS sg13_hv_nmos w=0.740u l=0.450u ng=1 ad=2.516e-13 as=2.516e-13 pd=2.16e-06 ps=2.16e-06 m=1
XN9 Q qint_b VSS VSS sg13_hv_nmos w=0.740u l=0.450u ng=1 ad=2.516e-13 as=2.516e-13 pd=2.16e-06 ps=2.16e-06 m=1
XN4 net61 Db VSS VSS sg13_hv_nmos w=0.640u l=0.450u ng=1 ad=2.176e-13 as=2.176e-13 pd=1.96e-06 ps=1.96e-06 m=1
XN6 net89 qint_b VSS VSS sg13_hv_nmos w=0.420u l=0.450u ng=1 ad=1.428e-13 as=1.428e-13 pd=1.52e-06 ps=1.52e-06 m=1
XN7 qint_b qint net116 VSS sg13_hv_nmos w=0.740u l=0.450u ng=1 ad=2.516e-13 as=2.516e-13 pd=2.16e-06 ps=2.16e-06 m=1
XN2 Db D VSS VSS sg13_hv_nmos w=0.550u l=0.450u ng=1 ad=1.87e-13 as=1.87e-13 pd=1.78e-06 ps=1.78e-06 m=1
XN0 gnb GATE_N VSS VSS sg13_hv_nmos w=0.740u l=0.450u ng=1 ad=2.516e-13 as=2.516e-13 pd=2.16e-06 ps=2.16e-06 m=1
XN1 gnbb gnb VSS VSS sg13_hv_nmos w=0.740u l=0.450u ng=1 ad=2.516e-13 as=2.516e-13 pd=2.16e-06 ps=2.16e-06 m=1
XP3 net59 Db VDD VDD sg13_hv_pmos w=2.400u l=0.450u ng=1 ad=8.16e-13 as=8.16e-13 pd=5.48e-06 ps=5.48e-06 m=1
XP8 qint_b RESET_B VDD VDD sg13_hv_pmos w=2.400u l=0.450u ng=1 ad=8.16e-13 as=8.16e-13 pd=5.48e-06 ps=5.48e-06 m=1
XP0 gnb GATE_N VDD VDD sg13_hv_pmos w=2.015u l=0.450u ng=1 ad=6.851e-13 as=6.851e-13 pd=4.71e-06 ps=4.71e-06 m=1
XP5 net92 qint_b VDD VDD sg13_hv_pmos w=1.010u l=0.450u ng=1 ad=3.434e-13 as=3.434e-13 pd=2.7e-06 ps=2.7e-06 m=1
XP7 qint_b qint VDD VDD sg13_hv_pmos w=2.400u l=0.450u ng=1 ad=8.16e-13 as=8.16e-13 pd=5.48e-06 ps=5.48e-06 m=1
XP9 Q qint_b VDD VDD sg13_hv_pmos w=2.690u l=0.450u ng=1 ad=9.146e-13 as=9.146e-13 pd=6.06e-06 ps=6.06e-06 m=1
XP4 qint gnbb net59 VDD sg13_hv_pmos w=2.400u l=0.450u ng=1 ad=8.16e-13 as=8.16e-13 pd=5.48e-06 ps=5.48e-06 m=1
XP2 Db D VDD VDD sg13_hv_pmos w=2.015u l=0.450u ng=1 ad=6.851e-13 as=6.851e-13 pd=4.71e-06 ps=4.71e-06 m=1
XP1 gnbb gnb VDD VDD sg13_hv_pmos w=2.015u l=0.450u ng=1 ad=6.851e-13 as=6.851e-13 pd=4.71e-06 ps=4.71e-06 m=1
XP6 qint gnb net92 VDD sg13_hv_pmos w=1.010u l=0.450u ng=1 ad=3.434e-13 as=3.434e-13 pd=2.7e-06 ps=2.7e-06 m=1
.ends
* End of subcircuit definition.

* Library name: sg13g2_stdcell_hv
* Cell name: sg13g2_hv_dlygate4sd1_1
* View name: schematic
.subckt sg13g2_hv_dlygate4sd1_1 X A VDD VSS
XP3 X net3 VDD VDD sg13_hv_pmos w=2.690u l=0.450u ng=1 ad=9.146e-13 as=9.146e-13 pd=6.06e-06 ps=6.06e-06 m=1
XP2 net3 net2 VDD VDD sg13_hv_pmos w=2.400u l=0.450u ng=1 ad=8.16e-13 as=8.16e-13 pd=5.48e-06 ps=5.48e-06 m=1
XP1 net2 net1 VDD VDD sg13_hv_pmos w=2.400u l=0.450u ng=1 ad=8.16e-13 as=8.16e-13 pd=5.48e-06 ps=5.48e-06 m=1
XP0 net1 A VDD VDD sg13_hv_pmos w=1.010u l=0.450u ng=1 ad=3.434e-13 as=3.434e-13 pd=2.7e-06 ps=2.7e-06 m=1
XN3 X net3 VSS VSS sg13_hv_nmos w=0.740u l=0.450u ng=1 ad=2.516e-13 as=2.516e-13 pd=2.16e-06 ps=2.16e-06 m=1
XN2 net3 net2 VSS VSS sg13_hv_nmos w=0.420u l=0.450u ng=1 ad=1.428e-13 as=1.428e-13 pd=1.52e-06 ps=1.52e-06 m=1
XN1 net2 net1 VSS VSS sg13_hv_nmos w=0.420u l=0.450u ng=1 ad=1.428e-13 as=1.428e-13 pd=1.52e-06 ps=1.52e-06 m=1
XN0 net1 A VSS VSS sg13_hv_nmos w=0.420u l=0.450u ng=1 ad=1.428e-13 as=1.428e-13 pd=1.52e-06 ps=1.52e-06 m=1
.ends
* End of subcircuit definition.

* Library name: sg13g2_stdcell_hv
* Cell name: sg13g2_hv_dlygate4sd2_1
* View name: schematic
.subckt sg13g2_hv_dlygate4sd2_1 X A VDD VSS
XP3 X net3 VDD VDD sg13_hv_pmos w=2.690u l=0.450u ng=1 ad=9.146e-13 as=9.146e-13 pd=6.06e-06 ps=6.06e-06 m=1
XP2 net3 net2 VDD VDD sg13_hv_pmos w=2.400u l=0.625u ng=1 ad=8.16e-13 as=8.16e-13 pd=5.48e-06 ps=5.48e-06 m=1
XP1 net2 net1 VDD VDD sg13_hv_pmos w=2.400u l=0.625u ng=1 ad=8.16e-13 as=8.16e-13 pd=5.48e-06 ps=5.48e-06 m=1
XP0 net1 A VDD VDD sg13_hv_pmos w=1.010u l=0.450u ng=1 ad=3.434e-13 as=3.434e-13 pd=2.7e-06 ps=2.7e-06 m=1
XN3 X net3 VSS VSS sg13_hv_nmos w=0.740u l=0.450u ng=1 ad=2.516e-13 as=2.516e-13 pd=2.16e-06 ps=2.16e-06 m=1
XN2 net3 net2 VSS VSS sg13_hv_nmos w=0.420u l=0.450u ng=1 ad=1.428e-13 as=1.428e-13 pd=1.52e-06 ps=1.52e-06 m=1
XN1 net2 net1 VSS VSS sg13_hv_nmos w=0.420u l=0.450u ng=1 ad=1.428e-13 as=1.428e-13 pd=1.52e-06 ps=1.52e-06 m=1
XN0 net1 A VSS VSS sg13_hv_nmos w=0.420u l=0.450u ng=1 ad=1.428e-13 as=1.428e-13 pd=1.52e-06 ps=1.52e-06 m=1
.ends
* End of subcircuit definition.

* Library name: sg13g2_stdcell_hv
* Cell name: sg13g2_hv_dlygate4sd3_1
* View name: schematic
.subckt sg13g2_hv_dlygate4sd3_1 X A VDD VSS
XP3 X net3 VDD VDD sg13_hv_pmos w=2.690u l=0.450u ng=1 ad=9.146e-13 as=9.146e-13 pd=6.06e-06 ps=6.06e-06 m=1
XP2 net3 net2 VDD VDD sg13_hv_pmos w=2.400u l=0.500u ng=1 ad=8.16e-13 as=8.16e-13 pd=5.48e-06 ps=5.48e-06 m=1
XP1 net2 net1 VDD VDD sg13_hv_pmos w=2.400u l=0.500u ng=1 ad=8.16e-13 as=8.16e-13 pd=5.48e-06 ps=5.48e-06 m=1
XP0 net1 A VDD VDD sg13_hv_pmos w=1.010u l=0.450u ng=1 ad=3.434e-13 as=3.434e-13 pd=2.7e-06 ps=2.7e-06 m=1
XN3 X net3 VSS VSS sg13_hv_nmos w=0.740u l=0.450u ng=1 ad=2.516e-13 as=2.516e-13 pd=2.16e-06 ps=2.16e-06 m=1
XN2 net3 net2 VSS VSS sg13_hv_nmos w=0.420u l=0.500u ng=1 ad=1.428e-13 as=1.428e-13 pd=1.52e-06 ps=1.52e-06 m=1
XN1 net2 net1 VSS VSS sg13_hv_nmos w=0.420u l=0.500u ng=1 ad=1.428e-13 as=1.428e-13 pd=1.52e-06 ps=1.52e-06 m=1
XN0 net1 A VSS VSS sg13_hv_nmos w=0.420u l=0.450u ng=1 ad=1.428e-13 as=1.428e-13 pd=1.52e-06 ps=1.52e-06 m=1
.ends
* End of subcircuit definition.

* Library name: sg13g2_stdcell_hv
* Cell name: sg13g2_hv_ebufn_2
* View name: schematic
.subckt sg13g2_hv_ebufn_2 Z A TE_B VDD VSS
XN3 net4 net3 VSS VSS sg13_hv_nmos w=1.480u l=0.450u ng=2 ad=2.812e-13 as=5.032e-13 pd=2.24e-06 ps=4.32e-06 m=1
XN2 Z net1 net4 VSS sg13_hv_nmos w=1.480u l=0.450u ng=2 ad=2.812e-13 as=5.032e-13 pd=2.24e-06 ps=4.32e-06 m=1
XN1 net3 TE_B VSS VSS sg13_hv_nmos w=0.640u l=0.450u ng=1 ad=2.176e-13 as=2.176e-13 pd=1.96e-06 ps=1.96e-06 m=1
XN0 net1 A VSS VSS sg13_hv_nmos w=0.640u l=0.450u ng=1 ad=2.176e-13 as=2.176e-13 pd=1.96e-06 ps=1.96e-06 m=1
XP2 net2 TE_B VDD VDD sg13_hv_pmos w=5.380u l=0.450u ng=2 ad=1.0222e-12 as=1.8292e-12 pd=6.14e-06 ps=1.212e-05 m=1
XP3 Z net1 net2 VDD sg13_hv_pmos w=5.380u l=0.450u ng=2 ad=1.0222e-12 as=1.8292e-12 pd=6.14e-06 ps=1.212e-05 m=1
XP1 net3 TE_B VDD VDD sg13_hv_pmos w=2.400u l=0.450u ng=1 ad=8.16e-13 as=8.16e-13 pd=5.48e-06 ps=5.48e-06 m=1
XP0 net1 A VDD VDD sg13_hv_pmos w=2.400u l=0.450u ng=1 ad=8.16e-13 as=8.16e-13 pd=5.48e-06 ps=5.48e-06 m=1
.ends
* End of subcircuit definition.

* Library name: sg13g2_stdcell_hv
* Cell name: sg13g2_hv_ebufn_4
* View name: schematic
.subckt sg13g2_hv_ebufn_4 Z A TE_B VDD VSS
XN0 net23 A VSS VSS sg13_hv_nmos w=0.740u l=0.450u ng=1 ad=2.516e-13 as=2.516e-13 pd=2.16e-06 ps=2.16e-06 m=1
XN1 net21 TE_B VSS VSS sg13_hv_nmos w=0.740u l=0.450u ng=1 ad=2.516e-13 as=2.516e-13 pd=2.16e-06 ps=2.16e-06 m=1
XN2 Z net23 net22 VSS sg13_hv_nmos w=2.960u l=0.450u ng=4 ad=5.624e-13 as=7.844e-13 pd=4.48e-06 ps=6.56e-06 m=1
XN3 net22 net21 VSS VSS sg13_hv_nmos w=2.960u l=0.450u ng=4 ad=5.624e-13 as=7.844e-13 pd=4.48e-06 ps=6.56e-06 m=1
XP0 net23 A VDD VDD sg13_hv_pmos w=2.690u l=0.450u ng=1 ad=9.146e-13 as=9.146e-13 pd=6.06e-06 ps=6.06e-06 m=1
XP1 net21 TE_B VDD VDD sg13_hv_pmos w=2.690u l=0.450u ng=1 ad=9.146e-13 as=9.146e-13 pd=6.06e-06 ps=6.06e-06 m=1
XP3 Z net23 net24 VDD sg13_hv_pmos w=10.760u l=0.450u ng=4 ad=2.0444e-12 as=2.8514e-12 pd=1.228e-05 ps=1.826e-05 m=1
XP2 net24 TE_B VDD VDD sg13_hv_pmos w=10.760u l=0.450u ng=4 ad=2.0444e-12 as=2.8514e-12 pd=1.228e-05 ps=1.826e-05 m=1
.ends
* End of subcircuit definition.

* Library name: sg13g2_stdcell_hv
* Cell name: sg13g2_hv_ebufn_8
* View name: schematic
.subckt sg13g2_hv_ebufn_8 Z A TE_B VDD VSS
XN3 net23 net22 VSS VSS sg13_hv_nmos w=5.920u l=0.450u ng=8 ad=1.1248e-12 as=1.3468e-12 pd=8.96e-06 ps=1.104e-05 m=1
XN2 Z net21 net23 VSS sg13_hv_nmos w=5.920u l=0.450u ng=8 ad=1.1248e-12 as=1.3468e-12 pd=8.96e-06 ps=1.104e-05 m=1
XN1 net22 TE_B VSS VSS sg13_hv_nmos w=0.740u l=0.450u ng=1 ad=2.516e-13 as=2.516e-13 pd=2.16e-06 ps=2.16e-06 m=1
XN0 net21 A VSS VSS sg13_hv_nmos w=1.480u l=0.450u ng=2 ad=2.812e-13 as=5.032e-13 pd=2.24e-06 ps=4.32e-06 m=1
XP2 net24 TE_B VDD VDD sg13_hv_pmos w=21.520u l=0.450u ng=8 ad=4.0888e-12 as=4.8958e-12 pd=2.456e-05 ps=3.054e-05 m=1
XP3 Z net21 net24 VDD sg13_hv_pmos w=21.520u l=0.450u ng=8 ad=4.0888e-12 as=4.8958e-12 pd=2.456e-05 ps=3.054e-05 m=1
XP1 net22 TE_B VDD VDD sg13_hv_pmos w=2.690u l=0.450u ng=1 ad=9.146e-13 as=9.146e-13 pd=6.06e-06 ps=6.06e-06 m=1
XP0 net21 A VDD VDD sg13_hv_pmos w=5.380u l=0.450u ng=2 ad=1.0222e-12 as=1.8292e-12 pd=6.14e-06 ps=1.212e-05 m=1
.ends
* End of subcircuit definition.

* Library name: sg13g2_stdcell_hv
* Cell name: sg13g2_hv_einvn_2
* View name: schematic
.subckt sg13g2_hv_einvn_2 Z A TE_B VDD VSS
XN0 TE TE_B VSS VSS sg13_hv_nmos w=0.420u l=0.450u ng=1 ad=1.428e-13 as=1.428e-13 pd=1.52e-06 ps=1.52e-06 m=1
XN2 net1 TE VSS VSS sg13_hv_nmos w=1.480u l=0.450u ng=2 ad=2.812e-13 as=5.032e-13 pd=2.24e-06 ps=4.32e-06 m=1
XN1 Z A net1 VSS sg13_hv_nmos w=1.480u l=0.450u ng=2 ad=2.812e-13 as=5.032e-13 pd=2.24e-06 ps=4.32e-06 m=1
XP0 TE TE_B VDD VDD sg13_hv_pmos w=1.535u l=0.450u ng=1 ad=5.219e-13 as=5.219e-13 pd=3.75e-06 ps=3.75e-06 m=1
XP1 net2 TE_B VDD VDD sg13_hv_pmos w=5.380u l=0.450u ng=2 ad=1.0222e-12 as=1.8292e-12 pd=6.14e-06 ps=1.212e-05 m=1
XP2 Z A net2 VDD sg13_hv_pmos w=5.380u l=0.450u ng=2 ad=1.0222e-12 as=1.8292e-12 pd=6.14e-06 ps=1.212e-05 m=1
.ends
* End of subcircuit definition.

* Library name: sg13g2_stdcell_hv
* Cell name: sg13g2_hv_einvn_4
* View name: schematic
.subckt sg13g2_hv_einvn_4 Z A TE_B VDD VSS
XN2 net16 TE VSS VSS sg13_hv_nmos w=2.960u l=0.450u ng=4 ad=5.624e-13 as=7.844e-13 pd=4.48e-06 ps=6.56e-06 m=1
XN0 TE TE_B VSS VSS sg13_hv_nmos w=0.740u l=0.450u ng=1 ad=2.516e-13 as=2.516e-13 pd=2.16e-06 ps=2.16e-06 m=1
XN1 Z A net16 VSS sg13_hv_nmos w=2.960u l=0.450u ng=4 ad=5.624e-13 as=7.844e-13 pd=4.48e-06 ps=6.56e-06 m=1
XP0 TE TE_B VDD VDD sg13_hv_pmos w=2.690u l=0.450u ng=1 ad=9.146e-13 as=9.146e-13 pd=6.06e-06 ps=6.06e-06 m=1
XP1 net17 TE_B VDD VDD sg13_hv_pmos w=10.760u l=0.450u ng=4 ad=2.0444e-12 as=2.8514e-12 pd=1.228e-05 ps=1.826e-05 m=1
XP2 Z A net17 VDD sg13_hv_pmos w=10.760u l=0.450u ng=4 ad=2.0444e-12 as=2.8514e-12 pd=1.228e-05 ps=1.826e-05 m=1
.ends
* End of subcircuit definition.

* Library name: sg13g2_stdcell_hv
* Cell name: sg13g2_hv_einvn_8
* View name: schematic
.subckt sg13g2_hv_einvn_8 Z A TE_B VDD VSS
XN1 Z A net29 VSS sg13_hv_nmos w=5.920u l=0.450u ng=8 ad=1.1248e-12 as=1.3468e-12 pd=8.96e-06 ps=1.104e-05 m=1
XN0 TE TE_B VSS VSS sg13_hv_nmos w=0.740u l=0.450u ng=1 ad=2.516e-13 as=2.516e-13 pd=2.16e-06 ps=2.16e-06 m=1
XN2 net29 TE VSS VSS sg13_hv_nmos w=5.920u l=0.450u ng=8 ad=1.1248e-12 as=1.3468e-12 pd=8.96e-06 ps=1.104e-05 m=1
XP1 net28 TE_B VDD VDD sg13_hv_pmos w=21.520u l=0.450u ng=8 ad=4.0888e-12 as=4.8958e-12 pd=2.456e-05 ps=3.054e-05 m=1
XP2 Z A net28 VDD sg13_hv_pmos w=21.520u l=0.450u ng=8 ad=4.0888e-12 as=4.8958e-12 pd=2.456e-05 ps=3.054e-05 m=1
XP0 TE TE_B VDD VDD sg13_hv_pmos w=2.690u l=0.450u ng=1 ad=9.146e-13 as=9.146e-13 pd=6.06e-06 ps=6.06e-06 m=1
.ends
* End of subcircuit definition.

* Library name: sg13g2_stdcell_hv
* Cell name: sg13g2_hv_inv_1
* View name: schematic
.subckt sg13g2_hv_inv_1 Y A VDD VSS
XN0 Y A VSS VSS sg13_hv_nmos w=0.740u l=0.450u ng=1 ad=2.516e-13 as=2.516e-13 pd=2.16e-06 ps=2.16e-06 m=1
XP0 Y A VDD VDD sg13_hv_pmos w=2.690u l=0.450u ng=1 ad=9.146e-13 as=9.146e-13 pd=6.06e-06 ps=6.06e-06 m=1
.ends
* End of subcircuit definition.

* Library name: sg13g2_stdcell_hv
* Cell name: sg13g2_hv_inv_16
* View name: schematic
.subckt sg13g2_hv_inv_16 Y A VDD VSS
XN0 Y A VSS VSS sg13_hv_nmos w=11.840u l=0.450u ng=16 ad=2.2496e-12 as=2.4716e-12 pd=1.792e-05 ps=2e-05 m=1
XP0 Y A VDD VDD sg13_hv_pmos w=43.040u l=0.450u ng=16 ad=8.1776e-12 as=8.9846e-12 pd=4.912e-05 ps=5.51e-05 m=1
.ends
* End of subcircuit definition.

* Library name: sg13g2_stdcell_hv
* Cell name: sg13g2_hv_inv_2
* View name: schematic
.subckt sg13g2_hv_inv_2 Y A VDD VSS
XN0 Y A VSS VSS sg13_hv_nmos w=1.480u l=0.450u ng=2 ad=2.812e-13 as=5.032e-13 pd=2.24e-06 ps=4.32e-06 m=1
XP0 Y A VDD VDD sg13_hv_pmos w=5.380u l=0.450u ng=2 ad=1.0222e-12 as=1.8292e-12 pd=6.14e-06 ps=1.212e-05 m=1
.ends
* End of subcircuit definition.

* Library name: sg13g2_stdcell_hv
* Cell name: sg13g2_hv_inv_4
* View name: schematic
.subckt sg13g2_hv_inv_4 Y A VDD VSS
XP0 Y A VDD VDD sg13_hv_pmos w=10.760u l=0.450u ng=4 ad=2.0444e-12 as=2.8514e-12 pd=1.228e-05 ps=1.826e-05 m=1
XN0 Y A VSS VSS sg13_hv_nmos w=2.960u l=0.450u ng=4 ad=5.624e-13 as=7.844e-13 pd=4.48e-06 ps=6.56e-06 m=1
.ends
* End of subcircuit definition.

* Library name: sg13g2_stdcell_hv
* Cell name: sg13g2_hv_inv_8
* View name: schematic
.subckt sg13g2_hv_inv_8 Y A VDD VSS
XN0 Y A VSS VSS sg13_hv_nmos w=5.920u l=0.450u ng=8 ad=1.1248e-12 as=1.3468e-12 pd=8.96e-06 ps=1.104e-05 m=1
XP0 Y A VDD VDD sg13_hv_pmos w=21.520u l=0.450u ng=8 ad=4.0888e-12 as=4.8958e-12 pd=2.456e-05 ps=3.054e-05 m=1
.ends
* End of subcircuit definition.

* Library name: sg13g2_stdcell_hv
* Cell name: sg13g2_hv_lgcp_1
* View name: schematic
.subckt sg13g2_hv_lgcp_1 GCLK CLK GATE VDD VSS
XP1 CLKBB CLKB VDD VDD sg13_hv_pmos w=2.015u l=0.450u ng=1 ad=6.851e-13 as=6.851e-13 pd=4.71e-06 ps=4.71e-06 m=1
XP3 net1 CLKBB net4 VDD sg13_hv_pmos w=2.400u l=0.450u ng=1 ad=8.16e-13 as=8.16e-13 pd=5.48e-06 ps=5.48e-06 m=1
XP4 int_GATE net1 VDD VDD sg13_hv_pmos w=2.690u l=0.450u ng=1 ad=9.146e-13 as=9.146e-13 pd=6.06e-06 ps=6.06e-06 m=1
XP2 net4 GATE VDD VDD sg13_hv_pmos w=2.400u l=0.450u ng=1 ad=8.16e-13 as=8.16e-13 pd=5.48e-06 ps=5.48e-06 m=1
XP8 net3 int_GATE VDD VDD sg13_hv_pmos w=2.015u l=0.450u ng=1 ad=6.851e-13 as=6.851e-13 pd=4.71e-06 ps=4.71e-06 m=1
XP9 GCLK net3 VDD VDD sg13_hv_pmos w=2.690u l=0.450u ng=1 ad=9.146e-13 as=9.146e-13 pd=6.06e-06 ps=6.06e-06 m=1
XP6 net1 CLKB net6 VDD sg13_hv_pmos w=1.010u l=0.450u ng=1 ad=3.434e-13 as=3.434e-13 pd=2.7e-06 ps=2.7e-06 m=1
XP0 CLKB CLK VDD VDD sg13_hv_pmos w=2.015u l=0.450u ng=1 ad=6.851e-13 as=6.851e-13 pd=4.71e-06 ps=4.71e-06 m=1
XP7 net3 CLK VDD VDD sg13_hv_pmos w=2.015u l=0.450u ng=1 ad=6.851e-13 as=6.851e-13 pd=4.71e-06 ps=4.71e-06 m=1
XP5 net6 int_GATE VDD VDD sg13_hv_pmos w=1.010u l=0.450u ng=1 ad=3.434e-13 as=3.434e-13 pd=2.7e-06 ps=2.7e-06 m=1
XN9 GCLK net3 VSS VSS sg13_hv_nmos w=0.740u l=0.450u ng=1 ad=2.516e-13 as=2.516e-13 pd=2.16e-06 ps=2.16e-06 m=1
XN7 net3 int_GATE net5 VSS sg13_hv_nmos w=0.640u l=0.450u ng=1 ad=2.176e-13 as=2.176e-13 pd=1.96e-06 ps=1.96e-06 m=1
XN4 int_GATE net1 VSS VSS sg13_hv_nmos w=0.740u l=0.450u ng=1 ad=2.516e-13 as=2.516e-13 pd=2.16e-06 ps=2.16e-06 m=1
XN1 CLKBB CLKB VSS VSS sg13_hv_nmos w=0.740u l=0.450u ng=1 ad=2.516e-13 as=2.516e-13 pd=2.16e-06 ps=2.16e-06 m=1
XN6 net7 int_GATE VSS VSS sg13_hv_nmos w=0.420u l=0.450u ng=1 ad=1.428e-13 as=1.428e-13 pd=1.52e-06 ps=1.52e-06 m=1
XN3 net2 GATE VSS VSS sg13_hv_nmos w=0.640u l=0.450u ng=1 ad=2.176e-13 as=2.176e-13 pd=1.96e-06 ps=1.96e-06 m=1
XN5 net1 CLKBB net7 VSS sg13_hv_nmos w=0.420u l=0.450u ng=1 ad=1.428e-13 as=1.428e-13 pd=1.52e-06 ps=1.52e-06 m=1
XN0 CLKB CLK VSS VSS sg13_hv_nmos w=0.740u l=0.450u ng=1 ad=2.516e-13 as=2.516e-13 pd=2.16e-06 ps=2.16e-06 m=1
XN8 net5 CLK VSS VSS sg13_hv_nmos w=0.640u l=0.450u ng=1 ad=2.176e-13 as=2.176e-13 pd=1.96e-06 ps=1.96e-06 m=1
XN2 net1 CLKB net2 VSS sg13_hv_nmos w=0.640u l=0.450u ng=1 ad=2.176e-13 as=2.176e-13 pd=1.96e-06 ps=1.96e-06 m=1
.ends
* End of subcircuit definition.

* Library name: sg13g2_stdcell_hv
* Cell name: sg13g2_hv_mux2_1
* View name: schematic
.subckt sg13g2_hv_mux2_1 X A0 A1 S VDD VSS
XP1 net4 S VDD VDD sg13_hv_pmos w=2.400u l=0.450u ng=1 ad=8.16e-13 as=8.16e-13 pd=5.48e-06 ps=5.48e-06 m=1
XP5 X net6 VDD VDD sg13_hv_pmos w=2.690u l=0.450u ng=1 ad=9.146e-13 as=9.146e-13 pd=6.06e-06 ps=6.06e-06 m=1
XP4 net6 A1 net5 VDD sg13_hv_pmos w=2.400u l=0.450u ng=1 ad=8.16e-13 as=8.16e-13 pd=5.48e-06 ps=5.48e-06 m=1
XP0 Sb S VDD VDD sg13_hv_pmos w=2.015u l=0.450u ng=1 ad=6.851e-13 as=6.851e-13 pd=4.71e-06 ps=4.71e-06 m=1
XP3 net5 Sb VDD VDD sg13_hv_pmos w=2.400u l=0.450u ng=1 ad=8.16e-13 as=8.16e-13 pd=5.48e-06 ps=5.48e-06 m=1
XP2 net6 A0 net4 VDD sg13_hv_pmos w=2.400u l=0.450u ng=1 ad=8.16e-13 as=8.16e-13 pd=5.48e-06 ps=5.48e-06 m=1
XN4 net3 S VSS VSS sg13_hv_nmos w=0.740u l=0.450u ng=1 ad=2.516e-13 as=2.516e-13 pd=2.16e-06 ps=2.16e-06 m=1
XN2 net1 Sb VSS VSS sg13_hv_nmos w=0.740u l=0.450u ng=1 ad=2.516e-13 as=2.516e-13 pd=2.16e-06 ps=2.16e-06 m=1
XN5 X net6 VSS VSS sg13_hv_nmos w=0.740u l=0.450u ng=1 ad=2.516e-13 as=2.516e-13 pd=2.16e-06 ps=2.16e-06 m=1
XN0 Sb S VSS VSS sg13_hv_nmos w=0.550u l=0.450u ng=1 ad=1.87e-13 as=1.87e-13 pd=1.78e-06 ps=1.78e-06 m=1
XN3 net6 A1 net3 VSS sg13_hv_nmos w=0.740u l=0.450u ng=1 ad=2.516e-13 as=2.516e-13 pd=2.16e-06 ps=2.16e-06 m=1
XN1 net6 A0 net1 VSS sg13_hv_nmos w=0.740u l=0.450u ng=1 ad=2.516e-13 as=2.516e-13 pd=2.16e-06 ps=2.16e-06 m=1
.ends
* End of subcircuit definition.

* Library name: sg13g2_stdcell_hv
* Cell name: sg13g2_hv_mux2_2
* View name: schematic
.subckt sg13g2_hv_mux2_2 X A0 A1 S VDD VSS
XP1 net4 S VDD VDD sg13_hv_pmos w=2.400u l=0.450u ng=1 ad=8.16e-13 as=8.16e-13 pd=5.48e-06 ps=5.48e-06 m=1
XP5 X net6 VDD VDD sg13_hv_pmos w=5.380u l=0.450u ng=2 ad=1.0222e-12 as=1.8292e-12 pd=6.14e-06 ps=1.212e-05 m=1
XP4 net6 A1 net5 VDD sg13_hv_pmos w=2.400u l=0.450u ng=1 ad=8.16e-13 as=8.16e-13 pd=5.48e-06 ps=5.48e-06 m=1
XP0 Sb S VDD VDD sg13_hv_pmos w=2.015u l=0.450u ng=1 ad=6.851e-13 as=6.851e-13 pd=4.71e-06 ps=4.71e-06 m=1
XP3 net5 Sb VDD VDD sg13_hv_pmos w=2.400u l=0.450u ng=1 ad=8.16e-13 as=8.16e-13 pd=5.48e-06 ps=5.48e-06 m=1
XP2 net6 A0 net4 VDD sg13_hv_pmos w=2.400u l=0.450u ng=1 ad=8.16e-13 as=8.16e-13 pd=5.48e-06 ps=5.48e-06 m=1
XN4 net3 S VSS VSS sg13_hv_nmos w=0.740u l=0.450u ng=1 ad=2.516e-13 as=2.516e-13 pd=2.16e-06 ps=2.16e-06 m=1
XN2 net1 Sb VSS VSS sg13_hv_nmos w=0.740u l=0.450u ng=1 ad=2.516e-13 as=2.516e-13 pd=2.16e-06 ps=2.16e-06 m=1
XN5 X net6 VSS VSS sg13_hv_nmos w=1.480u l=0.450u ng=2 ad=2.812e-13 as=5.032e-13 pd=2.24e-06 ps=4.32e-06 m=1
XN0 Sb S VSS VSS sg13_hv_nmos w=0.550u l=0.450u ng=1 ad=1.87e-13 as=1.87e-13 pd=1.78e-06 ps=1.78e-06 m=1
XN3 net6 A1 net3 VSS sg13_hv_nmos w=0.740u l=0.450u ng=1 ad=2.516e-13 as=2.516e-13 pd=2.16e-06 ps=2.16e-06 m=1
XN1 net6 A0 net1 VSS sg13_hv_nmos w=0.740u l=0.450u ng=1 ad=2.516e-13 as=2.516e-13 pd=2.16e-06 ps=2.16e-06 m=1
.ends
* End of subcircuit definition.

* Library name: sg13g2_stdcell_hv
* Cell name: sg13g2_hv_mux4_1
* View name: schematic
.subckt sg13g2_hv_mux4_1 X A0 A1 A2 A3 S0 S1 VDD VSS
XN12 X Xb VSS VSS sg13_hv_nmos w=0.740u l=0.450u ng=1 ad=2.516e-13 as=2.516e-13 pd=2.16e-06 ps=2.16e-06 m=1
XN2 low S0b net7 VSS sg13_hv_nmos w=0.640u l=0.450u ng=1 ad=2.176e-13 as=2.176e-13 pd=1.96e-06 ps=1.96e-06 m=1
XN3 net7 A0 VSS VSS sg13_hv_nmos w=0.640u l=0.450u ng=1 ad=2.176e-13 as=2.176e-13 pd=1.96e-06 ps=1.96e-06 m=1
XN6 low S1b Xb VSS sg13_hv_nmos w=0.640u l=0.450u ng=1 ad=2.176e-13 as=2.176e-13 pd=1.96e-06 ps=1.96e-06 m=1
XN11 high S1 Xb VSS sg13_hv_nmos w=0.640u l=0.450u ng=1 ad=2.176e-13 as=2.176e-13 pd=1.96e-06 ps=1.96e-06 m=1
XN10 net4 A3 VSS VSS sg13_hv_nmos w=0.640u l=0.450u ng=1 ad=2.176e-13 as=2.176e-13 pd=1.96e-06 ps=1.96e-06 m=1
XN9 high S0 net4 VSS sg13_hv_nmos w=0.640u l=0.450u ng=1 ad=2.176e-13 as=2.176e-13 pd=1.96e-06 ps=1.96e-06 m=1
XN8 net6 A2 VSS VSS sg13_hv_nmos w=0.640u l=0.450u ng=1 ad=2.176e-13 as=2.176e-13 pd=1.96e-06 ps=1.96e-06 m=1
XN7 high S0b net6 VSS sg13_hv_nmos w=0.640u l=0.450u ng=1 ad=2.176e-13 as=2.176e-13 pd=1.96e-06 ps=1.96e-06 m=1
XN5 net2 A1 VSS VSS sg13_hv_nmos w=0.640u l=0.450u ng=1 ad=2.176e-13 as=2.176e-13 pd=1.96e-06 ps=1.96e-06 m=1
XN4 low S0 net2 VSS sg13_hv_nmos w=0.640u l=0.450u ng=1 ad=2.176e-13 as=2.176e-13 pd=1.96e-06 ps=1.96e-06 m=1
XN1 S1b S1 VSS VSS sg13_hv_nmos w=0.640u l=0.450u ng=1 ad=2.176e-13 as=2.176e-13 pd=1.96e-06 ps=1.96e-06 m=1
XN0 S0b S0 VSS VSS sg13_hv_nmos w=0.640u l=0.450u ng=1 ad=2.176e-13 as=2.176e-13 pd=1.96e-06 ps=1.96e-06 m=1
XP6 low S1 Xb VDD sg13_hv_pmos w=2.400u l=0.450u ng=1 ad=8.16e-13 as=8.16e-13 pd=5.48e-06 ps=5.48e-06 m=1
XP11 high S1b Xb VDD sg13_hv_pmos w=2.400u l=0.450u ng=1 ad=8.16e-13 as=8.16e-13 pd=5.48e-06 ps=5.48e-06 m=1
XP12 X Xb VDD VDD sg13_hv_pmos w=2.690u l=0.450u ng=1 ad=9.146e-13 as=9.146e-13 pd=6.06e-06 ps=6.06e-06 m=1
XP10 high S0b net3 VDD sg13_hv_pmos w=2.400u l=0.450u ng=1 ad=8.16e-13 as=8.16e-13 pd=5.48e-06 ps=5.48e-06 m=1
XP9 net3 A3 VDD VDD sg13_hv_pmos w=2.400u l=0.450u ng=1 ad=8.16e-13 as=8.16e-13 pd=5.48e-06 ps=5.48e-06 m=1
XP8 high S0 net5 VDD sg13_hv_pmos w=2.400u l=0.450u ng=1 ad=8.16e-13 as=8.16e-13 pd=5.48e-06 ps=5.48e-06 m=1
XP7 net5 A2 VDD VDD sg13_hv_pmos w=2.400u l=0.450u ng=1 ad=8.16e-13 as=8.16e-13 pd=5.48e-06 ps=5.48e-06 m=1
XP2 net8 A0 VDD VDD sg13_hv_pmos w=2.400u l=0.450u ng=1 ad=8.16e-13 as=8.16e-13 pd=5.48e-06 ps=5.48e-06 m=1
XP3 low S0 net8 VDD sg13_hv_pmos w=2.400u l=0.450u ng=1 ad=8.16e-13 as=8.16e-13 pd=5.48e-06 ps=5.48e-06 m=1
XP1 S1b S1 VDD VDD sg13_hv_pmos w=2.400u l=0.450u ng=1 ad=8.16e-13 as=8.16e-13 pd=5.48e-06 ps=5.48e-06 m=1
XP0 S0b S0 VDD VDD sg13_hv_pmos w=2.400u l=0.450u ng=1 ad=8.16e-13 as=8.16e-13 pd=5.48e-06 ps=5.48e-06 m=1
XP5 low S0b net1 VDD sg13_hv_pmos w=2.400u l=0.450u ng=1 ad=8.16e-13 as=8.16e-13 pd=5.48e-06 ps=5.48e-06 m=1
XP4 net1 A1 VDD VDD sg13_hv_pmos w=2.400u l=0.450u ng=1 ad=8.16e-13 as=8.16e-13 pd=5.48e-06 ps=5.48e-06 m=1
.ends
* End of subcircuit definition.

* Library name: sg13g2_stdcell_hv
* Cell name: sg13g2_hv_nand2_1
* View name: schematic
.subckt sg13g2_hv_nand2_1 Y A B VDD VSS
XP1 Y B VDD VDD sg13_hv_pmos w=2.690u l=0.450u ng=1 ad=9.146e-13 as=9.146e-13 pd=6.06e-06 ps=6.06e-06 m=1
XP0 Y A VDD VDD sg13_hv_pmos w=2.690u l=0.450u ng=1 ad=9.146e-13 as=9.146e-13 pd=6.06e-06 ps=6.06e-06 m=1
XN1 net1 B VSS VSS sg13_hv_nmos w=0.740u l=0.450u ng=1 ad=2.516e-13 as=2.516e-13 pd=2.16e-06 ps=2.16e-06 m=1
XN0 Y A net1 VSS sg13_hv_nmos w=0.740u l=0.450u ng=1 ad=2.516e-13 as=2.516e-13 pd=2.16e-06 ps=2.16e-06 m=1
.ends
* End of subcircuit definition.

* Library name: sg13g2_stdcell_hv
* Cell name: sg13g2_hv_nand2_2
* View name: schematic
.subckt sg13g2_hv_nand2_2 Y A B VDD VSS
XP1 Y B VDD VDD sg13_hv_pmos w=5.380u l=0.450u ng=2 ad=1.0222e-12 as=1.8292e-12 pd=6.14e-06 ps=1.212e-05 m=1
XP0 Y A VDD VDD sg13_hv_pmos w=5.380u l=0.450u ng=2 ad=1.0222e-12 as=1.8292e-12 pd=6.14e-06 ps=1.212e-05 m=1
XN1 net1 B VSS VSS sg13_hv_nmos w=1.440u l=0.450u ng=2 ad=2.736e-13 as=4.896e-13 pd=2.2e-06 ps=4.24e-06 m=1
XN0 Y A net1 VSS sg13_hv_nmos w=1.440u l=0.450u ng=2 ad=2.736e-13 as=4.896e-13 pd=2.2e-06 ps=4.24e-06 m=1
.ends
* End of subcircuit definition.

* Library name: sg13g2_stdcell_hv
* Cell name: sg13g2_hv_nand2b_1
* View name: schematic
.subckt sg13g2_hv_nand2b_1 Y A_N B VDD VSS
XP2 Y net2 VDD VDD sg13_hv_pmos w=2.690u l=0.450u ng=1 ad=9.146e-13 as=9.146e-13 pd=6.06e-06 ps=6.06e-06 m=1
XP1 net2 A_N VDD VDD sg13_hv_pmos w=2.015u l=0.450u ng=1 ad=6.851e-13 as=6.851e-13 pd=4.71e-06 ps=4.71e-06 m=1
XP0 Y B VDD VDD sg13_hv_pmos w=2.690u l=0.450u ng=1 ad=9.146e-13 as=9.146e-13 pd=6.06e-06 ps=6.06e-06 m=1
XN1 Y net2 net1 VSS sg13_hv_nmos w=0.740u l=0.450u ng=1 ad=2.516e-13 as=2.516e-13 pd=2.16e-06 ps=2.16e-06 m=1
XN0 net2 A_N VSS VSS sg13_hv_nmos w=0.550u l=0.450u ng=1 ad=1.87e-13 as=1.87e-13 pd=1.78e-06 ps=1.78e-06 m=1
XN2 net1 B VSS VSS sg13_hv_nmos w=0.740u l=0.450u ng=1 ad=2.516e-13 as=2.516e-13 pd=2.16e-06 ps=2.16e-06 m=1
.ends
* End of subcircuit definition.

* Library name: sg13g2_stdcell_hv
* Cell name: sg13g2_hv_nand2b_2
* View name: schematic
.subckt sg13g2_hv_nand2b_2 Y A_N B VDD VSS
XP2 Y A VDD VDD sg13_hv_pmos w=5.380u l=0.450u ng=2 ad=1.0222e-12 as=1.8292e-12 pd=6.14e-06 ps=1.212e-05 m=1
XP0 A A_N VDD VDD sg13_hv_pmos w=2.015u l=0.450u ng=1 ad=6.851e-13 as=6.851e-13 pd=4.71e-06 ps=4.71e-06 m=1
XP1 Y B VDD VDD sg13_hv_pmos w=5.380u l=0.450u ng=2 ad=1.0222e-12 as=1.8292e-12 pd=6.14e-06 ps=1.212e-05 m=1
XN1 Y B net1 VSS sg13_hv_nmos w=1.440u l=0.450u ng=2 ad=2.736e-13 as=4.896e-13 pd=2.2e-06 ps=4.24e-06 m=1
XN0 A A_N VSS VSS sg13_hv_nmos w=0.550u l=0.450u ng=1 ad=1.87e-13 as=1.87e-13 pd=1.78e-06 ps=1.78e-06 m=1
XN2 net1 A VSS VSS sg13_hv_nmos w=1.440u l=0.450u ng=2 ad=2.736e-13 as=4.896e-13 pd=2.2e-06 ps=4.24e-06 m=1
.ends
* End of subcircuit definition.

* Library name: sg13g2_stdcell_hv
* Cell name: sg13g2_hv_nand3_1
* View name: schematic
.subckt sg13g2_hv_nand3_1 Y A B C VDD VSS
XP0 Y A VDD VDD sg13_hv_pmos w=2.690u l=0.450u ng=1 ad=9.146e-13 as=9.146e-13 pd=6.06e-06 ps=6.06e-06 m=1
XP1 Y B VDD VDD sg13_hv_pmos w=2.690u l=0.450u ng=1 ad=9.146e-13 as=9.146e-13 pd=6.06e-06 ps=6.06e-06 m=1
XP2 Y C VDD VDD sg13_hv_pmos w=2.690u l=0.450u ng=1 ad=9.146e-13 as=9.146e-13 pd=6.06e-06 ps=6.06e-06 m=1
XN1 net2 B net3 VSS sg13_hv_nmos w=0.740u l=0.450u ng=1 ad=2.516e-13 as=2.516e-13 pd=2.16e-06 ps=2.16e-06 m=1
XN2 net3 C VSS VSS sg13_hv_nmos w=0.740u l=0.450u ng=1 ad=2.516e-13 as=2.516e-13 pd=2.16e-06 ps=2.16e-06 m=1
XN0 Y A net2 VSS sg13_hv_nmos w=0.740u l=0.450u ng=1 ad=2.516e-13 as=2.516e-13 pd=2.16e-06 ps=2.16e-06 m=1
.ends
* End of subcircuit definition.

* Library name: sg13g2_stdcell_hv
* Cell name: sg13g2_hv_nand3b_1
* View name: schematic
.subckt sg13g2_hv_nand3b_1 Y A_N B C VDD VSS
XP0 net1 A_N VDD VDD sg13_hv_pmos w=2.015u l=0.450u ng=1 ad=6.851e-13 as=6.851e-13 pd=4.71e-06 ps=4.71e-06 m=1
XP1 Y net1 VDD VDD sg13_hv_pmos w=2.690u l=0.450u ng=1 ad=9.146e-13 as=9.146e-13 pd=6.06e-06 ps=6.06e-06 m=1
XP2 Y B VDD VDD sg13_hv_pmos w=2.690u l=0.450u ng=1 ad=9.146e-13 as=9.146e-13 pd=6.06e-06 ps=6.06e-06 m=1
XP3 Y C VDD VDD sg13_hv_pmos w=2.690u l=0.450u ng=1 ad=9.146e-13 as=9.146e-13 pd=6.06e-06 ps=6.06e-06 m=1
XN2 net2 B net3 VSS sg13_hv_nmos w=0.740u l=0.450u ng=1 ad=2.516e-13 as=2.516e-13 pd=2.16e-06 ps=2.16e-06 m=1
XN3 net3 C VSS VSS sg13_hv_nmos w=0.740u l=0.450u ng=1 ad=2.516e-13 as=2.516e-13 pd=2.16e-06 ps=2.16e-06 m=1
XN0 net1 A_N VSS VSS sg13_hv_nmos w=0.550u l=0.450u ng=1 ad=1.87e-13 as=1.87e-13 pd=1.78e-06 ps=1.78e-06 m=1
XN1 Y net1 net2 VSS sg13_hv_nmos w=0.740u l=0.450u ng=1 ad=2.516e-13 as=2.516e-13 pd=2.16e-06 ps=2.16e-06 m=1
.ends
* End of subcircuit definition.

* Library name: sg13g2_stdcell_hv
* Cell name: sg13g2_hv_nand4_1
* View name: schematic
.subckt sg13g2_hv_nand4_1 Y A B C D VDD VSS
XP3 Y D VDD VDD sg13_hv_pmos w=2.690u l=0.450u ng=1 ad=9.146e-13 as=9.146e-13 pd=6.06e-06 ps=6.06e-06 m=1
XP0 Y A VDD VDD sg13_hv_pmos w=2.690u l=0.450u ng=1 ad=9.146e-13 as=9.146e-13 pd=6.06e-06 ps=6.06e-06 m=1
XP1 Y B VDD VDD sg13_hv_pmos w=2.690u l=0.450u ng=1 ad=9.146e-13 as=9.146e-13 pd=6.06e-06 ps=6.06e-06 m=1
XP2 Y C VDD VDD sg13_hv_pmos w=2.690u l=0.450u ng=1 ad=9.146e-13 as=9.146e-13 pd=6.06e-06 ps=6.06e-06 m=1
XN1 net2 B net3 VSS sg13_hv_nmos w=0.740u l=0.450u ng=1 ad=2.516e-13 as=2.516e-13 pd=2.16e-06 ps=2.16e-06 m=1
XN2 net3 C net5 VSS sg13_hv_nmos w=0.740u l=0.450u ng=1 ad=2.516e-13 as=2.516e-13 pd=2.16e-06 ps=2.16e-06 m=1
XN0 Y A net2 VSS sg13_hv_nmos w=0.740u l=0.450u ng=1 ad=2.516e-13 as=2.516e-13 pd=2.16e-06 ps=2.16e-06 m=1
XN3 net5 D VSS VSS sg13_hv_nmos w=0.740u l=0.450u ng=1 ad=2.516e-13 as=2.516e-13 pd=2.16e-06 ps=2.16e-06 m=1
.ends
* End of subcircuit definition.

* Library name: sg13g2_stdcell_hv
* Cell name: sg13g2_hv_nor2_1
* View name: schematic
.subckt sg13g2_hv_nor2_1 Y A B VDD VSS
XN0 Y A VSS VSS sg13_hv_nmos w=0.740u l=0.450u ng=1 ad=2.516e-13 as=2.516e-13 pd=2.16e-06 ps=2.16e-06 m=1
XN1 Y B VSS VSS sg13_hv_nmos w=0.740u l=0.450u ng=1 ad=2.516e-13 as=2.516e-13 pd=2.16e-06 ps=2.16e-06 m=1
XP0 net1 A VDD VDD sg13_hv_pmos w=2.690u l=0.450u ng=1 ad=9.146e-13 as=9.146e-13 pd=6.06e-06 ps=6.06e-06 m=1
XP1 Y B net1 VDD sg13_hv_pmos w=2.690u l=0.450u ng=1 ad=9.146e-13 as=9.146e-13 pd=6.06e-06 ps=6.06e-06 m=1
.ends
* End of subcircuit definition.

* Library name: sg13g2_stdcell_hv
* Cell name: sg13g2_hv_nor2_2
* View name: schematic
.subckt sg13g2_hv_nor2_2 Y A B VDD VSS
XN0 Y A VSS VSS sg13_hv_nmos w=1.480u l=0.450u ng=2 ad=2.812e-13 as=5.032e-13 pd=2.24e-06 ps=4.32e-06 m=1
XN1 Y B VSS VSS sg13_hv_nmos w=1.480u l=0.450u ng=2 ad=2.812e-13 as=5.032e-13 pd=2.24e-06 ps=4.32e-06 m=1
XP0 net1 A VDD VDD sg13_hv_pmos w=5.380u l=0.450u ng=2 ad=1.0222e-12 as=1.8292e-12 pd=6.14e-06 ps=1.212e-05 m=1
XP1 Y B net1 VDD sg13_hv_pmos w=5.380u l=0.450u ng=2 ad=1.0222e-12 as=1.8292e-12 pd=6.14e-06 ps=1.212e-05 m=1
.ends
* End of subcircuit definition.

* Library name: sg13g2_stdcell_hv
* Cell name: sg13g2_hv_nor2b_1
* View name: schematic
.subckt sg13g2_hv_nor2b_1 Y A B_N VDD VSS
XN0 B B_N VSS VSS sg13_hv_nmos w=0.550u l=0.450u ng=1 ad=1.87e-13 as=1.87e-13 pd=1.78e-06 ps=1.78e-06 m=1
XN1 Y A VSS VSS sg13_hv_nmos w=0.740u l=0.450u ng=1 ad=2.516e-13 as=2.516e-13 pd=2.16e-06 ps=2.16e-06 m=1
XN2 Y B VSS VSS sg13_hv_nmos w=0.740u l=0.450u ng=1 ad=2.516e-13 as=2.516e-13 pd=2.16e-06 ps=2.16e-06 m=1
XP0 B B_N VDD VDD sg13_hv_pmos w=2.015u l=0.450u ng=1 ad=6.851e-13 as=6.851e-13 pd=4.71e-06 ps=4.71e-06 m=1
XP1 net1 B VDD VDD sg13_hv_pmos w=2.690u l=0.450u ng=1 ad=9.146e-13 as=9.146e-13 pd=6.06e-06 ps=6.06e-06 m=1
XP2 Y A net1 VDD sg13_hv_pmos w=2.690u l=0.450u ng=1 ad=9.146e-13 as=9.146e-13 pd=6.06e-06 ps=6.06e-06 m=1
.ends
* End of subcircuit definition.

* Library name: sg13g2_stdcell_hv
* Cell name: sg13g2_hv_nor2b_2
* View name: schematic
.subckt sg13g2_hv_nor2b_2 Y A B_N VDD VSS
XN0 B B_N VSS VSS sg13_hv_nmos w=0.640u l=0.450u ng=1 ad=2.176e-13 as=2.176e-13 pd=1.96e-06 ps=1.96e-06 m=1
XN1 Y A VSS VSS sg13_hv_nmos w=1.440u l=0.450u ng=2 ad=2.736e-13 as=4.896e-13 pd=2.2e-06 ps=4.24e-06 m=1
XN2 Y B VSS VSS sg13_hv_nmos w=1.440u l=0.450u ng=2 ad=2.736e-13 as=4.896e-13 pd=2.2e-06 ps=4.24e-06 m=1
XP0 B B_N VDD VDD sg13_hv_pmos w=2.400u l=0.450u ng=1 ad=8.16e-13 as=8.16e-13 pd=5.48e-06 ps=5.48e-06 m=1
XP1 net1 B VDD VDD sg13_hv_pmos w=5.380u l=0.450u ng=2 ad=1.0222e-12 as=1.8292e-12 pd=6.14e-06 ps=1.212e-05 m=1
XP2 Y A net1 VDD sg13_hv_pmos w=5.380u l=0.450u ng=2 ad=1.0222e-12 as=1.8292e-12 pd=6.14e-06 ps=1.212e-05 m=1
.ends
* End of subcircuit definition.

* Library name: sg13g2_stdcell_hv
* Cell name: sg13g2_hv_nor3_1
* View name: schematic
.subckt sg13g2_hv_nor3_1 Y A B C VDD VSS
XP2 Y C net2 VDD sg13_hv_pmos w=2.690u l=0.450u ng=1 ad=9.146e-13 as=9.146e-13 pd=6.06e-06 ps=6.06e-06 m=1
XP1 net2 B net3 VDD sg13_hv_pmos w=2.690u l=0.450u ng=1 ad=9.146e-13 as=9.146e-13 pd=6.06e-06 ps=6.06e-06 m=1
XP0 net3 A VDD VDD sg13_hv_pmos w=2.690u l=0.450u ng=1 ad=9.146e-13 as=9.146e-13 pd=6.06e-06 ps=6.06e-06 m=1
XN0 Y A VSS VSS sg13_hv_nmos w=0.770u l=0.450u ng=1 ad=2.618e-13 as=2.618e-13 pd=2.22e-06 ps=2.22e-06 m=1
XN1 Y B VSS VSS sg13_hv_nmos w=0.770u l=0.450u ng=1 ad=2.618e-13 as=2.618e-13 pd=2.22e-06 ps=2.22e-06 m=1
XN2 Y C VSS VSS sg13_hv_nmos w=0.770u l=0.450u ng=1 ad=2.618e-13 as=2.618e-13 pd=2.22e-06 ps=2.22e-06 m=1
.ends
* End of subcircuit definition.

* Library name: sg13g2_stdcell_hv
* Cell name: sg13g2_hv_nor3_2
* View name: schematic
.subckt sg13g2_hv_nor3_2 Y A B C VDD VSS
XP2 Y C net2 VDD sg13_hv_pmos w=5.380u l=0.450u ng=2 ad=1.0222e-12 as=1.8292e-12 pd=6.14e-06 ps=1.212e-05 m=1
XP1 net2 B net3 VDD sg13_hv_pmos w=5.380u l=0.450u ng=2 ad=1.0222e-12 as=1.8292e-12 pd=6.14e-06 ps=1.212e-05 m=1
XP0 net3 A VDD VDD sg13_hv_pmos w=5.380u l=0.450u ng=2 ad=1.0222e-12 as=1.8292e-12 pd=6.14e-06 ps=1.212e-05 m=1
XN0 Y A VSS VSS sg13_hv_nmos w=1.480u l=0.450u ng=2 ad=2.812e-13 as=5.032e-13 pd=2.24e-06 ps=4.32e-06 m=1
XN1 Y B VSS VSS sg13_hv_nmos w=1.480u l=0.450u ng=2 ad=2.812e-13 as=5.032e-13 pd=2.24e-06 ps=4.32e-06 m=1
XN2 Y C VSS VSS sg13_hv_nmos w=1.480u l=0.450u ng=2 ad=2.812e-13 as=5.032e-13 pd=2.24e-06 ps=4.32e-06 m=1
.ends
* End of subcircuit definition.

* Library name: sg13g2_stdcell_hv
* Cell name: sg13g2_hv_nor4_1
* View name: schematic
.subckt sg13g2_hv_nor4_1 Y A B C D VDD VSS
XP0 net3 A VDD VDD sg13_hv_pmos w=2.690u l=0.450u ng=1 ad=9.146e-13 as=9.146e-13 pd=6.06e-06 ps=6.06e-06 m=1
XP1 net2 B net3 VDD sg13_hv_pmos w=2.690u l=0.450u ng=1 ad=9.146e-13 as=9.146e-13 pd=6.06e-06 ps=6.06e-06 m=1
XP2 net1 C net2 VDD sg13_hv_pmos w=2.690u l=0.450u ng=1 ad=9.146e-13 as=9.146e-13 pd=6.06e-06 ps=6.06e-06 m=1
XP3 Y D net1 VDD sg13_hv_pmos w=2.690u l=0.450u ng=1 ad=9.146e-13 as=9.146e-13 pd=6.06e-06 ps=6.06e-06 m=1
XN0 Y A VSS VSS sg13_hv_nmos w=0.740u l=0.450u ng=1 ad=2.516e-13 as=2.516e-13 pd=2.16e-06 ps=2.16e-06 m=1
XN3 Y D VSS VSS sg13_hv_nmos w=0.740u l=0.450u ng=1 ad=2.516e-13 as=2.516e-13 pd=2.16e-06 ps=2.16e-06 m=1
XN1 Y B VSS VSS sg13_hv_nmos w=0.740u l=0.450u ng=1 ad=2.516e-13 as=2.516e-13 pd=2.16e-06 ps=2.16e-06 m=1
XN2 Y C VSS VSS sg13_hv_nmos w=0.740u l=0.450u ng=1 ad=2.516e-13 as=2.516e-13 pd=2.16e-06 ps=2.16e-06 m=1
.ends
* End of subcircuit definition.

* Library name: sg13g2_stdcell_hv
* Cell name: sg13g2_hv_nor4_2
* View name: schematic
.subckt sg13g2_hv_nor4_2 Y A B C D VDD VSS
XP0 net3 A VDD VDD sg13_hv_pmos w=5.380u l=0.450u ng=2 ad=1.0222e-12 as=1.8292e-12 pd=6.14e-06 ps=1.212e-05 m=1
XP1 net2 B net3 VDD sg13_hv_pmos w=5.380u l=0.450u ng=2 ad=1.0222e-12 as=1.8292e-12 pd=6.14e-06 ps=1.212e-05 m=1
XP2 net1 C net2 VDD sg13_hv_pmos w=5.380u l=0.450u ng=2 ad=1.0222e-12 as=1.8292e-12 pd=6.14e-06 ps=1.212e-05 m=1
XP3 Y D net1 VDD sg13_hv_pmos w=5.380u l=0.450u ng=2 ad=1.0222e-12 as=1.8292e-12 pd=6.14e-06 ps=1.212e-05 m=1
XN0 Y A VSS VSS sg13_hv_nmos w=1.480u l=0.450u ng=2 ad=2.812e-13 as=5.032e-13 pd=2.24e-06 ps=4.32e-06 m=1
XN3 Y D VSS VSS sg13_hv_nmos w=1.480u l=0.450u ng=2 ad=2.812e-13 as=5.032e-13 pd=2.24e-06 ps=4.32e-06 m=1
XN1 Y B VSS VSS sg13_hv_nmos w=1.480u l=0.450u ng=2 ad=2.812e-13 as=5.032e-13 pd=2.24e-06 ps=4.32e-06 m=1
XN2 Y C VSS VSS sg13_hv_nmos w=1.480u l=0.450u ng=2 ad=2.812e-13 as=5.032e-13 pd=2.24e-06 ps=4.32e-06 m=1
.ends
* End of subcircuit definition.

* Library name: sg13g2_stdcell_hv
* Cell name: sg13g2_hv_o21ai_1
* View name: schematic
.subckt sg13g2_hv_o21ai_1 Y A1 A2 B1 VDD VSS
XP0 net14 A1 VDD VDD sg13_hv_pmos w=2.690u l=0.450u ng=1 ad=9.146e-13 as=9.146e-13 pd=6.06e-06 ps=6.06e-06 m=1
XP1 Y A2 net14 VDD sg13_hv_pmos w=2.690u l=0.450u ng=1 ad=9.146e-13 as=9.146e-13 pd=6.06e-06 ps=6.06e-06 m=1
XP2 Y B1 VDD VDD sg13_hv_pmos w=2.690u l=0.450u ng=1 ad=9.146e-13 as=9.146e-13 pd=6.06e-06 ps=6.06e-06 m=1
XN0 net1 A2 VSS VSS sg13_hv_nmos w=0.740u l=0.450u ng=1 ad=2.516e-13 as=2.516e-13 pd=2.16e-06 ps=2.16e-06 m=1
XN2 net1 A1 VSS VSS sg13_hv_nmos w=0.740u l=0.450u ng=1 ad=2.516e-13 as=2.516e-13 pd=2.16e-06 ps=2.16e-06 m=1
XN1 Y B1 net1 VSS sg13_hv_nmos w=0.740u l=0.450u ng=1 ad=2.516e-13 as=2.516e-13 pd=2.16e-06 ps=2.16e-06 m=1
.ends
* End of subcircuit definition.

* Library name: sg13g2_stdcell_hv
* Cell name: sg13g2_hv_or2_1
* View name: schematic
.subckt sg13g2_hv_or2_1 X A B VDD VSS
XP1 net2 B net3 VDD sg13_hv_pmos w=2.015u l=0.450u ng=1 ad=6.851e-13 as=6.851e-13 pd=4.71e-06 ps=4.71e-06 m=1
XP0 net3 A VDD VDD sg13_hv_pmos w=2.015u l=0.450u ng=1 ad=6.851e-13 as=6.851e-13 pd=4.71e-06 ps=4.71e-06 m=1
XP2 X net2 VDD VDD sg13_hv_pmos w=2.690u l=0.450u ng=1 ad=9.146e-13 as=9.146e-13 pd=6.06e-06 ps=6.06e-06 m=1
XN1 net2 A VSS VSS sg13_hv_nmos w=0.550u l=0.450u ng=1 ad=1.87e-13 as=1.87e-13 pd=1.78e-06 ps=1.78e-06 m=1
XN0 net2 B VSS VSS sg13_hv_nmos w=0.550u l=0.450u ng=1 ad=1.87e-13 as=1.87e-13 pd=1.78e-06 ps=1.78e-06 m=1
XN2 X net2 VSS VSS sg13_hv_nmos w=0.740u l=0.450u ng=1 ad=2.516e-13 as=2.516e-13 pd=2.16e-06 ps=2.16e-06 m=1
.ends
* End of subcircuit definition.

* Library name: sg13g2_stdcell_hv
* Cell name: sg13g2_hv_or2_2
* View name: schematic
.subckt sg13g2_hv_or2_2 X A B VDD VSS
XP1 net2 B net3 VDD sg13_hv_pmos w=2.015u l=0.450u ng=1 ad=6.851e-13 as=6.851e-13 pd=4.71e-06 ps=4.71e-06 m=1
XP0 net3 A VDD VDD sg13_hv_pmos w=2.015u l=0.450u ng=1 ad=6.851e-13 as=6.851e-13 pd=4.71e-06 ps=4.71e-06 m=1
XP2 X net2 VDD VDD sg13_hv_pmos w=5.380u l=0.450u ng=2 ad=1.0222e-12 as=1.8292e-12 pd=6.14e-06 ps=1.212e-05 m=1
XN1 net2 A VSS VSS sg13_hv_nmos w=0.550u l=0.450u ng=1 ad=1.87e-13 as=1.87e-13 pd=1.78e-06 ps=1.78e-06 m=1
XN0 net2 B VSS VSS sg13_hv_nmos w=0.550u l=0.450u ng=1 ad=1.87e-13 as=1.87e-13 pd=1.78e-06 ps=1.78e-06 m=1
XN2 X net2 VSS VSS sg13_hv_nmos w=1.480u l=0.450u ng=2 ad=2.812e-13 as=5.032e-13 pd=2.24e-06 ps=4.32e-06 m=1
.ends
* End of subcircuit definition.

* Library name: sg13g2_stdcell_hv
* Cell name: sg13g2_hv_or3_1
* View name: schematic
.subckt sg13g2_hv_or3_1 X A B C VDD VSS
XN2 net1 C VSS VSS sg13_hv_nmos w=0.550u l=0.450u ng=1 ad=1.87e-13 as=1.87e-13 pd=1.78e-06 ps=1.78e-06 m=1
XN3 X net1 VSS VSS sg13_hv_nmos w=0.740u l=0.450u ng=1 ad=2.516e-13 as=2.516e-13 pd=2.16e-06 ps=2.16e-06 m=1
XN1 net1 B VSS VSS sg13_hv_nmos w=0.550u l=0.450u ng=1 ad=1.87e-13 as=1.87e-13 pd=1.78e-06 ps=1.78e-06 m=1
XN0 net1 A VSS VSS sg13_hv_nmos w=0.550u l=0.450u ng=1 ad=1.87e-13 as=1.87e-13 pd=1.78e-06 ps=1.78e-06 m=1
XP3 X net1 VDD VDD sg13_hv_pmos w=2.690u l=0.450u ng=1 ad=9.146e-13 as=9.146e-13 pd=6.06e-06 ps=6.06e-06 m=1
XP1 net9 B net12 VDD sg13_hv_pmos w=2.400u l=0.450u ng=1 ad=8.16e-13 as=8.16e-13 pd=5.48e-06 ps=5.48e-06 m=1
XP0 net12 A VDD VDD sg13_hv_pmos w=2.400u l=0.450u ng=1 ad=8.16e-13 as=8.16e-13 pd=5.48e-06 ps=5.48e-06 m=1
XP2 net1 C net9 VDD sg13_hv_pmos w=2.400u l=0.450u ng=1 ad=8.16e-13 as=8.16e-13 pd=5.48e-06 ps=5.48e-06 m=1
.ends
* End of subcircuit definition.

* Library name: sg13g2_stdcell_hv
* Cell name: sg13g2_hv_or3_2
* View name: schematic
.subckt sg13g2_hv_or3_2 X A B C VDD VSS
XN2 net1 C VSS VSS sg13_hv_nmos w=0.550u l=0.450u ng=1 ad=1.87e-13 as=1.87e-13 pd=1.78e-06 ps=1.78e-06 m=1
XN3 X net1 VSS VSS sg13_hv_nmos w=1.480u l=0.450u ng=2 ad=2.812e-13 as=5.032e-13 pd=2.24e-06 ps=4.32e-06 m=1
XN1 net1 B VSS VSS sg13_hv_nmos w=0.550u l=0.450u ng=1 ad=1.87e-13 as=1.87e-13 pd=1.78e-06 ps=1.78e-06 m=1
XN0 net1 A VSS VSS sg13_hv_nmos w=0.550u l=0.450u ng=1 ad=1.87e-13 as=1.87e-13 pd=1.78e-06 ps=1.78e-06 m=1
XP3 X net1 VDD VDD sg13_hv_pmos w=5.380u l=0.450u ng=2 ad=1.0222e-12 as=1.8292e-12 pd=6.14e-06 ps=1.212e-05 m=1
XP1 net9 B net12 VDD sg13_hv_pmos w=2.400u l=0.450u ng=1 ad=8.16e-13 as=8.16e-13 pd=5.48e-06 ps=5.48e-06 m=1
XP0 net12 A VDD VDD sg13_hv_pmos w=2.400u l=0.450u ng=1 ad=8.16e-13 as=8.16e-13 pd=5.48e-06 ps=5.48e-06 m=1
XP2 net1 C net9 VDD sg13_hv_pmos w=2.400u l=0.450u ng=1 ad=8.16e-13 as=8.16e-13 pd=5.48e-06 ps=5.48e-06 m=1
.ends
* End of subcircuit definition.

* Library name: sg13g2_stdcell_hv
* Cell name: sg13g2_hv_or4_1
* View name: schematic
.subckt sg13g2_hv_or4_1 X A B C D VDD VSS
XN4 X net1 VSS VSS sg13_hv_nmos w=0.740u l=0.450u ng=1 ad=2.516e-13 as=2.516e-13 pd=2.16e-06 ps=2.16e-06 m=1
XN3 net1 D VSS VSS sg13_hv_nmos w=0.550u l=0.450u ng=1 ad=1.87e-13 as=1.87e-13 pd=1.78e-06 ps=1.78e-06 m=1
XN2 net1 C VSS VSS sg13_hv_nmos w=0.550u l=0.450u ng=1 ad=1.87e-13 as=1.87e-13 pd=1.78e-06 ps=1.78e-06 m=1
XN1 net1 B VSS VSS sg13_hv_nmos w=0.550u l=0.450u ng=1 ad=1.87e-13 as=1.87e-13 pd=1.78e-06 ps=1.78e-06 m=1
XN0 net1 A VSS VSS sg13_hv_nmos w=0.550u l=0.450u ng=1 ad=1.87e-13 as=1.87e-13 pd=1.78e-06 ps=1.78e-06 m=1
XP0 net4 A VDD VDD sg13_hv_pmos w=2.400u l=0.450u ng=1 ad=8.16e-13 as=8.16e-13 pd=5.48e-06 ps=5.48e-06 m=1
XP1 net3 B net4 VDD sg13_hv_pmos w=2.400u l=0.450u ng=1 ad=8.16e-13 as=8.16e-13 pd=5.48e-06 ps=5.48e-06 m=1
XP2 net2 C net3 VDD sg13_hv_pmos w=2.400u l=0.450u ng=1 ad=8.16e-13 as=8.16e-13 pd=5.48e-06 ps=5.48e-06 m=1
XP3 net1 D net2 VDD sg13_hv_pmos w=2.400u l=0.450u ng=1 ad=8.16e-13 as=8.16e-13 pd=5.48e-06 ps=5.48e-06 m=1
XP4 X net1 VDD VDD sg13_hv_pmos w=2.690u l=0.450u ng=1 ad=9.146e-13 as=9.146e-13 pd=6.06e-06 ps=6.06e-06 m=1
.ends
* End of subcircuit definition.

* Library name: sg13g2_stdcell_hv
* Cell name: sg13g2_hv_or4_2
* View name: schematic
.subckt sg13g2_hv_or4_2 X A B C D VDD VSS
XN4 X net1 VSS VSS sg13_hv_nmos w=1.480u l=0.450u ng=2 ad=2.812e-13 as=5.032e-13 pd=2.24e-06 ps=4.32e-06 m=1
XN3 net1 D VSS VSS sg13_hv_nmos w=0.550u l=0.450u ng=1 ad=1.87e-13 as=1.87e-13 pd=1.78e-06 ps=1.78e-06 m=1
XN2 net1 C VSS VSS sg13_hv_nmos w=0.550u l=0.450u ng=1 ad=1.87e-13 as=1.87e-13 pd=1.78e-06 ps=1.78e-06 m=1
XN1 net1 B VSS VSS sg13_hv_nmos w=0.550u l=0.450u ng=1 ad=1.87e-13 as=1.87e-13 pd=1.78e-06 ps=1.78e-06 m=1
XN0 net1 A VSS VSS sg13_hv_nmos w=0.550u l=0.450u ng=1 ad=1.87e-13 as=1.87e-13 pd=1.78e-06 ps=1.78e-06 m=1
XP0 net4 A VDD VDD sg13_hv_pmos w=2.400u l=0.450u ng=1 ad=8.16e-13 as=8.16e-13 pd=5.48e-06 ps=5.48e-06 m=1
XP1 net3 B net4 VDD sg13_hv_pmos w=2.400u l=0.450u ng=1 ad=8.16e-13 as=8.16e-13 pd=5.48e-06 ps=5.48e-06 m=1
XP2 net2 C net3 VDD sg13_hv_pmos w=2.400u l=0.450u ng=1 ad=8.16e-13 as=8.16e-13 pd=5.48e-06 ps=5.48e-06 m=1
XP3 net1 D net2 VDD sg13_hv_pmos w=2.400u l=0.450u ng=1 ad=8.16e-13 as=8.16e-13 pd=5.48e-06 ps=5.48e-06 m=1
XP4 X net1 VDD VDD sg13_hv_pmos w=5.380u l=0.450u ng=2 ad=1.0222e-12 as=1.8292e-12 pd=6.14e-06 ps=1.212e-05 m=1
.ends
* End of subcircuit definition.

* Library name: sg13g2_stdcell_hv
* Cell name: sg13g2_hv_sdfbbp_1
* View name: schematic
.subckt sg13g2_hv_sdfbbp_1 Q Q_N CLK D RESET_B SCD SCE SET_B VDD VSS
XP1 resetbb RESET_B VDD VDD sg13_hv_pmos w=1.535u l=0.450u ng=1 ad=5.219e-13 as=5.219e-13 pd=3.75e-06 ps=3.75e-06 m=1
XP19 pre_q DbbLatch2 net8 VDD sg13_hv_pmos w=2.400u l=0.450u ng=1 ad=8.16e-13 as=8.16e-13 pd=5.48e-06 ps=5.48e-06 m=1
XP20 pre_q SET_B VDD VDD sg13_hv_pmos w=2.400u l=0.450u ng=1 ad=8.16e-13 as=8.16e-13 pd=5.48e-06 ps=5.48e-06 m=1
XP3 CLKbb CLKb VDD VDD sg13_hv_pmos w=2.690u l=0.450u ng=1 ad=9.146e-13 as=9.146e-13 pd=6.06e-06 ps=6.06e-06 m=1
XP0 SCEb SCE VDD VDD sg13_hv_pmos w=1.535u l=0.450u ng=1 ad=5.219e-13 as=5.219e-13 pd=3.75e-06 ps=3.75e-06 m=1
XP7 Db D net3 VDD sg13_hv_pmos w=1.535u l=0.450u ng=1 ad=5.219e-13 as=5.219e-13 pd=3.75e-06 ps=3.75e-06 m=1
XP13 DbbTG CLKb net10 VDD sg13_hv_pmos w=1.010u l=0.450u ng=1 ad=3.434e-13 as=3.434e-13 pd=2.7e-06 ps=2.7e-06 m=1
XP12 net10 DbLatchM VDD VDD sg13_hv_pmos w=1.010u l=0.450u ng=1 ad=3.434e-13 as=3.434e-13 pd=2.7e-06 ps=2.7e-06 m=1
XP6 net3 SCE VDD VDD sg13_hv_pmos w=1.535u l=0.450u ng=1 ad=5.219e-13 as=5.219e-13 pd=3.75e-06 ps=3.75e-06 m=1
XP21 Q_N pre_q VDD VDD sg13_hv_pmos w=2.690u l=0.450u ng=1 ad=9.146e-13 as=9.146e-13 pd=6.06e-06 ps=6.06e-06 m=1
XP14 net1 DbLatchM VDD VDD sg13_hv_pmos w=2.015u l=0.450u ng=1 ad=6.851e-13 as=6.851e-13 pd=4.71e-06 ps=4.71e-06 m=1
XP18 net8 resetbb VDD VDD sg13_hv_pmos w=2.400u l=0.450u ng=1 ad=8.16e-13 as=8.16e-13 pd=5.48e-06 ps=5.48e-06 m=1
XP11 DbLatchM SET_B VDD VDD sg13_hv_pmos w=2.015u l=0.450u ng=1 ad=6.851e-13 as=6.851e-13 pd=4.71e-06 ps=4.71e-06 m=1
XP4 net2 SCD VDD VDD sg13_hv_pmos w=1.535u l=0.450u ng=1 ad=5.219e-13 as=5.219e-13 pd=3.75e-06 ps=3.75e-06 m=1
XP2 CLKb CLK VDD VDD sg13_hv_pmos w=2.690u l=0.450u ng=1 ad=9.146e-13 as=9.146e-13 pd=6.06e-06 ps=6.06e-06 m=1
XP10 DbLatchM DbbTG net7 VDD sg13_hv_pmos w=2.015u l=0.450u ng=1 ad=6.851e-13 as=6.851e-13 pd=4.71e-06 ps=4.71e-06 m=1
XP8 Db CLKbb DbbTG VDD sg13_hv_pmos w=1.535u l=0.450u ng=1 ad=5.219e-13 as=5.219e-13 pd=3.75e-06 ps=3.75e-06 m=1
XP5 Db SCEb net2 VDD sg13_hv_pmos w=1.535u l=0.450u ng=1 ad=5.219e-13 as=5.219e-13 pd=3.75e-06 ps=3.75e-06 m=1
XP22 pre_qb pre_q VDD VDD sg13_hv_pmos w=2.015u l=0.450u ng=1 ad=6.851e-13 as=6.851e-13 pd=4.71e-06 ps=4.71e-06 m=1
XP9 net7 resetbb VDD VDD sg13_hv_pmos w=2.015u l=0.450u ng=1 ad=6.851e-13 as=6.851e-13 pd=4.71e-06 ps=4.71e-06 m=1
XP16 net6 pre_q VDD VDD sg13_hv_pmos w=1.010u l=0.450u ng=1 ad=3.434e-13 as=3.434e-13 pd=2.7e-06 ps=2.7e-06 m=1
XP17 DbbLatch2 CLKbb net6 VDD sg13_hv_pmos w=1.010u l=0.450u ng=1 ad=3.434e-13 as=3.434e-13 pd=2.7e-06 ps=2.7e-06 m=1
XP15 DbbLatch2 CLKb net1 VDD sg13_hv_pmos w=2.015u l=0.450u ng=1 ad=6.851e-13 as=6.851e-13 pd=4.71e-06 ps=4.71e-06 m=1
XP23 Q pre_qb VDD VDD sg13_hv_pmos w=2.690u l=0.450u ng=1 ad=9.146e-13 as=9.146e-13 pd=6.06e-06 ps=6.06e-06 m=1
XN4 Db SCE net5 VSS sg13_hv_nmos w=0.420u l=0.450u ng=1 ad=1.428e-13 as=1.428e-13 pd=1.52e-06 ps=1.52e-06 m=1
XN5 net5 SCD VSS VSS sg13_hv_nmos w=0.420u l=0.450u ng=1 ad=1.428e-13 as=1.428e-13 pd=1.52e-06 ps=1.52e-06 m=1
XN18 pre_q DbbLatch2 net11 VSS sg13_hv_nmos w=0.740u l=0.450u ng=1 ad=2.516e-13 as=2.516e-13 pd=2.16e-06 ps=2.16e-06 m=1
XN8 Db CLKb DbbTG VSS sg13_hv_nmos w=0.420u l=0.450u ng=1 ad=1.428e-13 as=1.428e-13 pd=1.52e-06 ps=1.52e-06 m=1
XN7 net4 SCEb VSS VSS sg13_hv_nmos w=0.420u l=0.450u ng=1 ad=1.428e-13 as=1.428e-13 pd=1.52e-06 ps=1.52e-06 m=1
XN3 CLKbb CLKb VSS VSS sg13_hv_nmos w=0.740u l=0.450u ng=1 ad=2.516e-13 as=2.516e-13 pd=2.16e-06 ps=2.16e-06 m=1
XN1 resetbb RESET_B VSS VSS sg13_hv_nmos w=0.420u l=0.450u ng=1 ad=1.428e-13 as=1.428e-13 pd=1.52e-06 ps=1.52e-06 m=1
XN17 net14 pre_q VSS VSS sg13_hv_nmos w=0.420u l=0.450u ng=1 ad=1.428e-13 as=1.428e-13 pd=1.52e-06 ps=1.52e-06 m=1
XN9 DbLatchM DbbTG net12 VSS sg13_hv_nmos w=0.550u l=0.450u ng=1 ad=1.87e-13 as=1.87e-13 pd=1.78e-06 ps=1.78e-06 m=1
XN0 SCEb SCE VSS VSS sg13_hv_nmos w=0.420u l=0.450u ng=1 ad=1.428e-13 as=1.428e-13 pd=1.52e-06 ps=1.52e-06 m=1
XN10 net12 SET_B VSS VSS sg13_hv_nmos w=0.550u l=0.450u ng=1 ad=1.87e-13 as=1.87e-13 pd=1.78e-06 ps=1.78e-06 m=1
XN13 net15 DbLatchM VSS VSS sg13_hv_nmos w=0.420u l=0.450u ng=1 ad=1.428e-13 as=1.428e-13 pd=1.52e-06 ps=1.52e-06 m=1
XN19 net11 SET_B VSS VSS sg13_hv_nmos w=0.740u l=0.450u ng=1 ad=2.516e-13 as=2.516e-13 pd=2.16e-06 ps=2.16e-06 m=1
XN12 DbbTG CLKbb net15 VSS sg13_hv_nmos w=0.420u l=0.450u ng=1 ad=1.428e-13 as=1.428e-13 pd=1.52e-06 ps=1.52e-06 m=1
XN6 Db D net4 VSS sg13_hv_nmos w=0.420u l=0.450u ng=1 ad=1.428e-13 as=1.428e-13 pd=1.52e-06 ps=1.52e-06 m=1
XN22 pre_qb pre_q VSS VSS sg13_hv_nmos w=0.550u l=0.450u ng=1 ad=1.87e-13 as=1.87e-13 pd=1.78e-06 ps=1.78e-06 m=1
XN16 DbbLatch2 CLKb net14 VSS sg13_hv_nmos w=0.420u l=0.450u ng=1 ad=1.428e-13 as=1.428e-13 pd=1.52e-06 ps=1.52e-06 m=1
XN23 Q pre_qb VSS VSS sg13_hv_nmos w=0.740u l=0.450u ng=1 ad=2.516e-13 as=2.516e-13 pd=2.16e-06 ps=2.16e-06 m=1
XN15 net13 DbLatchM VSS VSS sg13_hv_nmos w=0.550u l=0.450u ng=1 ad=1.87e-13 as=1.87e-13 pd=1.78e-06 ps=1.78e-06 m=1
XN2 CLKb CLK VSS VSS sg13_hv_nmos w=0.740u l=0.450u ng=1 ad=2.516e-13 as=2.516e-13 pd=2.16e-06 ps=2.16e-06 m=1
XN14 DbbLatch2 CLKbb net13 VSS sg13_hv_nmos w=0.550u l=0.450u ng=1 ad=1.87e-13 as=1.87e-13 pd=1.78e-06 ps=1.78e-06 m=1
XN11 DbLatchM resetbb net12 VSS sg13_hv_nmos w=0.550u l=0.450u ng=1 ad=1.87e-13 as=1.87e-13 pd=1.78e-06 ps=1.78e-06 m=1
XN21 Q_N pre_q VSS VSS sg13_hv_nmos w=0.740u l=0.450u ng=1 ad=2.516e-13 as=2.516e-13 pd=2.16e-06 ps=2.16e-06 m=1
XN20 pre_q resetbb net11 VSS sg13_hv_nmos w=0.740u l=0.450u ng=1 ad=2.516e-13 as=2.516e-13 pd=2.16e-06 ps=2.16e-06 m=1
.ends
* End of subcircuit definition.

* Library name: sg13g2_stdcell_hv
* Cell name: sg13g2_hv_sighold
* View name: schematic
.subckt sg13g2_hv_sighold SH VDD VSS
XN1 net1 SH VSS VSS sg13_hv_nmos w=0.300u l=0.450u ng=1 ad=1.02e-13 as=1.02e-13 pd=1.28e-06 ps=1.28e-06 m=1
XN0 SH net1 VSS VSS sg13_hv_nmos w=0.300u l=0.700u ng=1 ad=1.02e-13 as=1.02e-13 pd=1.28e-06 ps=1.28e-06 m=1
XP1 net1 SH VDD VDD sg13_hv_pmos w=1.080u l=0.450u ng=1 ad=3.672e-13 as=3.672e-13 pd=2.84e-06 ps=2.84e-06 m=1
XP0 SH net1 VDD VDD sg13_hv_pmos w=0.720u l=0.700u ng=1 ad=2.448e-13 as=2.448e-13 pd=2.12e-06 ps=2.12e-06 m=1
.ends
* End of subcircuit definition.

* Library name: sg13g2_stdcell_hv
* Cell name: sg13g2_hv_slgcp_1
* View name: schematic
.subckt sg13g2_hv_slgcp_1 GCLK CLK GATE SCE VDD VSS
XP10 GCLK net5 VDD VDD sg13_hv_pmos w=2.690u l=0.450u ng=1 ad=9.146e-13 as=9.146e-13 pd=6.06e-06 ps=6.06e-06 m=1
XP4 net1 CLKbb net6 VDD sg13_hv_pmos w=2.015u l=0.450u ng=1 ad=6.851e-13 as=6.851e-13 pd=4.71e-06 ps=4.71e-06 m=1
XP1 CLKbb CLKb VDD VDD sg13_hv_pmos w=2.015u l=0.450u ng=1 ad=6.851e-13 as=6.851e-13 pd=4.71e-06 ps=4.71e-06 m=1
XP8 net5 int_GATE VDD VDD sg13_hv_pmos w=2.015u l=0.450u ng=1 ad=6.851e-13 as=6.851e-13 pd=4.71e-06 ps=4.71e-06 m=1
XP2 net3 SCE VDD VDD sg13_hv_pmos w=2.015u l=0.450u ng=1 ad=6.851e-13 as=6.851e-13 pd=4.71e-06 ps=4.71e-06 m=1
XP7 net6 CLKb net4 VDD sg13_hv_pmos w=1.010u l=0.450u ng=1 ad=3.434e-13 as=3.434e-13 pd=2.7e-06 ps=2.7e-06 m=1
XP5 int_GATE net6 VDD VDD sg13_hv_pmos w=2.690u l=0.450u ng=1 ad=9.146e-13 as=9.146e-13 pd=6.06e-06 ps=6.06e-06 m=1
XP0 CLKb CLK VDD VDD sg13_hv_pmos w=2.015u l=0.450u ng=1 ad=6.851e-13 as=6.851e-13 pd=4.71e-06 ps=4.71e-06 m=1
XP9 net5 CLK VDD VDD sg13_hv_pmos w=2.015u l=0.450u ng=1 ad=6.851e-13 as=6.851e-13 pd=4.71e-06 ps=4.71e-06 m=1
XP6 net4 int_GATE VDD VDD sg13_hv_pmos w=1.010u l=0.450u ng=1 ad=3.434e-13 as=3.434e-13 pd=2.7e-06 ps=2.7e-06 m=1
XP3 net1 GATE net3 VDD sg13_hv_pmos w=2.015u l=0.450u ng=1 ad=6.851e-13 as=6.851e-13 pd=4.71e-06 ps=4.71e-06 m=1
XN5 int_GATE net6 VSS VSS sg13_hv_nmos w=0.740u l=0.450u ng=1 ad=2.516e-13 as=2.516e-13 pd=2.16e-06 ps=2.16e-06 m=1
XN9 net2 CLK VSS VSS sg13_hv_nmos w=0.640u l=0.450u ng=1 ad=2.176e-13 as=2.176e-13 pd=1.96e-06 ps=1.96e-06 m=1
XN2 net1 SCE VSS VSS sg13_hv_nmos w=0.550u l=0.450u ng=1 ad=1.87e-13 as=1.87e-13 pd=1.78e-06 ps=1.78e-06 m=1
XN4 net6 CLKb net1 VSS sg13_hv_nmos w=0.550u l=0.450u ng=1 ad=1.87e-13 as=1.87e-13 pd=1.78e-06 ps=1.78e-06 m=1
XN7 net7 int_GATE VSS VSS sg13_hv_nmos w=0.420u l=0.450u ng=1 ad=1.428e-13 as=1.428e-13 pd=1.52e-06 ps=1.52e-06 m=1
XN8 net5 int_GATE net2 VSS sg13_hv_nmos w=0.640u l=0.450u ng=1 ad=2.176e-13 as=2.176e-13 pd=1.96e-06 ps=1.96e-06 m=1
XN10 GCLK net5 VSS VSS sg13_hv_nmos w=0.740u l=0.450u ng=1 ad=2.516e-13 as=2.516e-13 pd=2.16e-06 ps=2.16e-06 m=1
XN1 CLKbb CLKb VSS VSS sg13_hv_nmos w=0.740u l=0.450u ng=1 ad=2.516e-13 as=2.516e-13 pd=2.16e-06 ps=2.16e-06 m=1
XN3 net1 GATE VSS VSS sg13_hv_nmos w=0.550u l=0.450u ng=1 ad=1.87e-13 as=1.87e-13 pd=1.78e-06 ps=1.78e-06 m=1
XN0 CLKb CLK VSS VSS sg13_hv_nmos w=0.740u l=0.450u ng=1 ad=2.516e-13 as=2.516e-13 pd=2.16e-06 ps=2.16e-06 m=1
XN6 net6 CLKbb net7 VSS sg13_hv_nmos w=0.420u l=0.450u ng=1 ad=1.428e-13 as=1.428e-13 pd=1.52e-06 ps=1.52e-06 m=1
.ends
* End of subcircuit definition.

* Library name: sg13g2_stdcell_hv
* Cell name: sg13g2_hv_tiehi
* View name: schematic
* End of subcircuit definition.

* Library name: sg13g2_stdcell_hv
* Cell name: sg13g2_hv_tielo
* View name: schematic
* End of subcircuit definition.

* Library name: sg13g2_stdcell_hv
* Cell name: sg13g2_hv_xnor2_1
* View name: schematic
.subckt sg13g2_hv_xnor2_1 Y A B VDD VSS
XP4 Y net1 VDD VDD sg13_hv_pmos w=2.690u l=0.450u ng=1 ad=9.146e-13 as=9.146e-13 pd=6.06e-06 ps=6.06e-06 m=1
XP3 Y B net4 VDD sg13_hv_pmos w=2.690u l=0.450u ng=1 ad=9.146e-13 as=9.146e-13 pd=6.06e-06 ps=6.06e-06 m=1
XP2 net4 A VDD VDD sg13_hv_pmos w=2.690u l=0.450u ng=1 ad=9.146e-13 as=9.146e-13 pd=6.06e-06 ps=6.06e-06 m=1
XP1 net1 B VDD VDD sg13_hv_pmos w=2.015u l=0.450u ng=1 ad=6.851e-13 as=6.851e-13 pd=4.71e-06 ps=4.71e-06 m=1
XP0 net1 A VDD VDD sg13_hv_pmos w=2.015u l=0.450u ng=1 ad=6.851e-13 as=6.851e-13 pd=4.71e-06 ps=4.71e-06 m=1
XN3 Y net1 net3 VSS sg13_hv_nmos w=0.740u l=0.450u ng=1 ad=2.516e-13 as=2.516e-13 pd=2.16e-06 ps=2.16e-06 m=1
XN1 net2 A VSS VSS sg13_hv_nmos w=0.640u l=0.450u ng=1 ad=2.176e-13 as=2.176e-13 pd=1.96e-06 ps=1.96e-06 m=1
XN0 net1 B net2 VSS sg13_hv_nmos w=0.640u l=0.450u ng=1 ad=2.176e-13 as=2.176e-13 pd=1.96e-06 ps=1.96e-06 m=1
XN4 net3 B VSS VSS sg13_hv_nmos w=0.740u l=0.450u ng=1 ad=2.516e-13 as=2.516e-13 pd=2.16e-06 ps=2.16e-06 m=1
XN2 net3 A VSS VSS sg13_hv_nmos w=0.740u l=0.450u ng=1 ad=2.516e-13 as=2.516e-13 pd=2.16e-06 ps=2.16e-06 m=1
.ends
* End of subcircuit definition.

* Library name: sg13g2_stdcell_hv
* Cell name: sg13g2_hv_xor2_1
* View name: schematic
.subckt sg13g2_hv_xor2_1 X A B VDD VSS
XN0 net1 A VSS VSS sg13_hv_nmos w=0.550u l=0.450u ng=1 ad=1.87e-13 as=1.87e-13 pd=1.78e-06 ps=1.78e-06 m=1
XN3 X B net3 VSS sg13_hv_nmos w=0.740u l=0.450u ng=1 ad=2.516e-13 as=2.516e-13 pd=2.16e-06 ps=2.16e-06 m=1
XN2 X net1 VSS VSS sg13_hv_nmos w=0.740u l=0.450u ng=1 ad=2.516e-13 as=2.516e-13 pd=2.16e-06 ps=2.16e-06 m=1
XN4 net3 A VSS VSS sg13_hv_nmos w=0.740u l=0.450u ng=1 ad=2.516e-13 as=2.516e-13 pd=2.16e-06 ps=2.16e-06 m=1
XN1 net1 B VSS VSS sg13_hv_nmos w=0.550u l=0.450u ng=1 ad=1.87e-13 as=1.87e-13 pd=1.78e-06 ps=1.78e-06 m=1
XP0 net6 A VDD VDD sg13_hv_pmos w=2.400u l=0.450u ng=1 ad=8.16e-13 as=8.16e-13 pd=5.48e-06 ps=5.48e-06 m=1
XP1 net1 B net6 VDD sg13_hv_pmos w=2.400u l=0.450u ng=1 ad=8.16e-13 as=8.16e-13 pd=5.48e-06 ps=5.48e-06 m=1
XP2 net5 A VDD VDD sg13_hv_pmos w=2.690u l=0.450u ng=1 ad=9.146e-13 as=9.146e-13 pd=6.06e-06 ps=6.06e-06 m=1
XP4 net5 B VDD VDD sg13_hv_pmos w=2.690u l=0.450u ng=1 ad=9.146e-13 as=9.146e-13 pd=6.06e-06 ps=6.06e-06 m=1
XP3 X net1 net5 VDD sg13_hv_pmos w=2.690u l=0.450u ng=1 ad=9.146e-13 as=9.146e-13 pd=6.06e-06 ps=6.06e-06 m=1
.ends
* End of subcircuit definition.

* Library name: sg13g2_stdcell_hv
* Cell name: sg13g2_hv_a22oi_1
* View name: schematic
.subckt sg13g2_hv_a22oi_1 Y A1 A2 B1 B2 VDD VSS
XN1 net1 B1 VSS VSS sg13_hv_nmos w=0.740u l=0.450u ng=1 ad=2.516e-13 as=2.516e-13 pd=2.16e-06 ps=2.16e-06 m=1
XN0 Y B2 net1 VSS sg13_hv_nmos w=0.740u l=0.450u ng=1 ad=2.516e-13 as=2.516e-13 pd=2.16e-06 ps=2.16e-06 m=1
XN3 net2 A2 VSS VSS sg13_hv_nmos w=0.740u l=0.450u ng=1 ad=2.516e-13 as=2.516e-13 pd=2.16e-06 ps=2.16e-06 m=1
XN2 Y A1 net2 VSS sg13_hv_nmos w=0.740u l=0.450u ng=1 ad=2.516e-13 as=2.516e-13 pd=2.16e-06 ps=2.16e-06 m=1
XP1 Y B1 net3 VDD sg13_hv_pmos w=2.690u l=0.450u ng=1 ad=9.146e-13 as=9.146e-13 pd=6.06e-06 ps=6.06e-06 m=1
XP3 Y B2 net3 VDD sg13_hv_pmos w=2.690u l=0.450u ng=1 ad=9.146e-13 as=9.146e-13 pd=6.06e-06 ps=6.06e-06 m=1
XP2 net3 A2 VDD VDD sg13_hv_pmos w=2.690u l=0.450u ng=1 ad=9.146e-13 as=9.146e-13 pd=6.06e-06 ps=6.06e-06 m=1
XP0 net3 A1 VDD VDD sg13_hv_pmos w=2.690u l=0.450u ng=1 ad=9.146e-13 as=9.146e-13 pd=6.06e-06 ps=6.06e-06 m=1
.ends
* End of subcircuit definition.

* Library name: sg13g2_stdcell_hv
* Cell name: sg13g2_hv_sdfrbpq_1
* View name: schematic
.subckt sg13g2_hv_sdfrbpq_1 Q CLK D RESET_B SCD SCE VDD VSS
XN3 Db SCD net63 VSS sg13_hv_nmos w=0.740u l=0.450u ng=1 ad=2.516e-13 as=2.516e-13 pd=2.16e-06 ps=2.16e-06 m=1
XN1 Db D net65 VSS sg13_hv_nmos w=0.740u l=0.450u ng=1 ad=2.516e-13 as=2.516e-13 pd=2.16e-06 ps=2.16e-06 m=1
XN0 SCEb SCE VSS VSS sg13_hv_nmos w=0.550u l=0.450u ng=1 ad=1.87e-13 as=1.87e-13 pd=1.78e-06 ps=1.78e-06 m=1
XN4 net63 SCE VSS VSS sg13_hv_nmos w=0.740u l=0.450u ng=1 ad=2.516e-13 as=2.516e-13 pd=2.16e-06 ps=2.16e-06 m=1
XN2 net65 SCEb VSS VSS sg13_hv_nmos w=0.740u l=0.450u ng=1 ad=2.516e-13 as=2.516e-13 pd=2.16e-06 ps=2.16e-06 m=1
XN17 net12 net2 VSS VSS sg13_hv_nmos w=0.420u l=0.450u ng=1 ad=1.428e-13 as=1.428e-13 pd=1.52e-06 ps=1.52e-06 m=1
XN16 net5 clkneg net12 VSS sg13_hv_nmos w=0.420u l=0.450u ng=1 ad=1.428e-13 as=1.428e-13 pd=1.52e-06 ps=1.52e-06 m=1
XN18 net2 net5 net11 VSS sg13_hv_nmos w=0.420u l=0.450u ng=1 ad=1.428e-13 as=1.428e-13 pd=1.52e-06 ps=1.52e-06 m=1
XN19 net11 RESET_B VSS VSS sg13_hv_nmos w=0.420u l=0.450u ng=1 ad=1.428e-13 as=1.428e-13 pd=1.52e-06 ps=1.52e-06 m=1
XN20 Q net2 VSS VSS sg13_hv_nmos w=0.740u l=0.450u ng=1 ad=2.516e-13 as=2.516e-13 pd=2.16e-06 ps=2.16e-06 m=1
XN6 Dbbb Dbb net10 VSS sg13_hv_nmos w=0.420u l=0.450u ng=1 ad=1.428e-13 as=1.428e-13 pd=1.52e-06 ps=1.52e-06 m=1
XN7 net10 RESET_B VSS VSS sg13_hv_nmos w=0.420u l=0.450u ng=1 ad=1.428e-13 as=1.428e-13 pd=1.52e-06 ps=1.52e-06 m=1
XN10 Dbbb clkneg net6 VSS sg13_hv_nmos w=0.420u l=0.450u ng=1 ad=1.428e-13 as=1.428e-13 pd=1.52e-06 ps=1.52e-06 m=1
XN11 net6 clkpos net9 VSS sg13_hv_nmos w=0.420u l=0.450u ng=1 ad=1.428e-13 as=1.428e-13 pd=1.52e-06 ps=1.52e-06 m=1
XN12 net9 net4 net8 VSS sg13_hv_nmos w=0.420u l=0.450u ng=1 ad=1.428e-13 as=1.428e-13 pd=1.52e-06 ps=1.52e-06 m=1
XN13 net8 RESET_B VSS VSS sg13_hv_nmos w=0.420u l=0.450u ng=1 ad=1.428e-13 as=1.428e-13 pd=1.52e-06 ps=1.52e-06 m=1
XN14 net4 net6 VSS VSS sg13_hv_nmos w=0.740u l=0.450u ng=1 ad=2.516e-13 as=2.516e-13 pd=2.16e-06 ps=2.16e-06 m=1
XN8 clkneg CLK VSS VSS sg13_hv_nmos w=0.740u l=0.450u ng=1 ad=2.516e-13 as=2.516e-13 pd=2.16e-06 ps=2.16e-06 m=1
XN15 net4 clkpos net5 VSS sg13_hv_nmos w=0.740u l=0.450u ng=1 ad=2.516e-13 as=2.516e-13 pd=2.16e-06 ps=2.16e-06 m=1
XN9 clkpos clkneg VSS VSS sg13_hv_nmos w=0.740u l=0.450u ng=1 ad=2.516e-13 as=2.516e-13 pd=2.16e-06 ps=2.16e-06 m=1
XN5 Dbb Db VSS VSS sg13_hv_nmos w=0.740u l=0.450u ng=1 ad=2.516e-13 as=2.516e-13 pd=2.16e-06 ps=2.16e-06 m=1
XP1 net64 SCE VDD VDD sg13_hv_pmos w=2.400u l=0.450u ng=1 ad=8.16e-13 as=8.16e-13 pd=5.48e-06 ps=5.48e-06 m=1
XP3 net62 SCEb VDD VDD sg13_hv_pmos w=2.400u l=0.450u ng=1 ad=8.16e-13 as=8.16e-13 pd=5.48e-06 ps=5.48e-06 m=1
XP0 SCEb SCE VDD VDD sg13_hv_pmos w=2.015u l=0.450u ng=1 ad=6.851e-13 as=6.851e-13 pd=4.71e-06 ps=4.71e-06 m=1
XP4 Db SCD net62 VDD sg13_hv_pmos w=2.400u l=0.450u ng=1 ad=8.16e-13 as=8.16e-13 pd=5.48e-06 ps=5.48e-06 m=1
XP2 Db D net64 VDD sg13_hv_pmos w=2.400u l=0.450u ng=1 ad=8.16e-13 as=8.16e-13 pd=5.48e-06 ps=5.48e-06 m=1
XP17 net5 clkpos net3 VDD sg13_hv_pmos w=1.010u l=0.450u ng=1 ad=3.434e-13 as=3.434e-13 pd=2.7e-06 ps=2.7e-06 m=1
XP18 net2 net5 VDD VDD sg13_hv_pmos w=1.010u l=0.450u ng=1 ad=3.434e-13 as=3.434e-13 pd=2.7e-06 ps=2.7e-06 m=1
XP19 net2 RESET_B VDD VDD sg13_hv_pmos w=1.010u l=0.450u ng=1 ad=3.434e-13 as=3.434e-13 pd=2.7e-06 ps=2.7e-06 m=1
XP20 Q net2 VDD VDD sg13_hv_pmos w=2.690u l=0.450u ng=1 ad=9.146e-13 as=9.146e-13 pd=6.06e-06 ps=6.06e-06 m=1
XP10 Dbbb clkpos net6 VDD sg13_hv_pmos w=1.010u l=0.450u ng=1 ad=3.434e-13 as=3.434e-13 pd=2.7e-06 ps=2.7e-06 m=1
XP6 Dbbb RESET_B VDD VDD sg13_hv_pmos w=1.010u l=0.450u ng=1 ad=3.434e-13 as=3.434e-13 pd=2.7e-06 ps=2.7e-06 m=1
XP7 Dbbb Dbb VDD VDD sg13_hv_pmos w=1.010u l=0.450u ng=1 ad=3.434e-13 as=3.434e-13 pd=2.7e-06 ps=2.7e-06 m=1
XP11 net7 net4 VDD VDD sg13_hv_pmos w=1.010u l=0.450u ng=1 ad=3.434e-13 as=3.434e-13 pd=2.7e-06 ps=2.7e-06 m=1
XP12 net6 clkneg net7 VDD sg13_hv_pmos w=1.010u l=0.450u ng=1 ad=3.434e-13 as=3.434e-13 pd=2.7e-06 ps=2.7e-06 m=1
XP13 net6 RESET_B VDD VDD sg13_hv_pmos w=1.010u l=0.450u ng=1 ad=3.434e-13 as=3.434e-13 pd=2.7e-06 ps=2.7e-06 m=1
XP8 clkneg CLK VDD VDD sg13_hv_pmos w=2.690u l=0.450u ng=1 ad=9.146e-13 as=9.146e-13 pd=6.06e-06 ps=6.06e-06 m=1
XP9 clkpos clkneg VDD VDD sg13_hv_pmos w=2.690u l=0.450u ng=1 ad=9.146e-13 as=9.146e-13 pd=6.06e-06 ps=6.06e-06 m=1
XP14 net4 net6 VDD VDD sg13_hv_pmos w=2.400u l=0.450u ng=1 ad=8.16e-13 as=8.16e-13 pd=5.48e-06 ps=5.48e-06 m=1
XP15 net4 clkneg net5 VDD sg13_hv_pmos w=2.400u l=0.450u ng=1 ad=8.16e-13 as=8.16e-13 pd=5.48e-06 ps=5.48e-06 m=1
XP5 Dbb Db VDD VDD sg13_hv_pmos w=2.690u l=0.450u ng=1 ad=9.146e-13 as=9.146e-13 pd=6.06e-06 ps=6.06e-06 m=1
XP16 net3 net2 VDD VDD sg13_hv_pmos w=1.010u l=0.450u ng=1 ad=3.434e-13 as=3.434e-13 pd=2.7e-06 ps=2.7e-06 m=1
.ends
* End of subcircuit definition.

* Library name: sg13g2_stdcell_hv
* Cell name: sg13g2_hv_sdfrbpq_2
* View name: schematic
.subckt sg13g2_hv_sdfrbpq_2 Q CLK D RESET_B SCD SCE VDD VSS
XN3 Db SCD net63 VSS sg13_hv_nmos w=0.740u l=0.450u ng=1 ad=2.516e-13 as=2.516e-13 pd=2.16e-06 ps=2.16e-06 m=1
XN1 Db D net65 VSS sg13_hv_nmos w=0.740u l=0.450u ng=1 ad=2.516e-13 as=2.516e-13 pd=2.16e-06 ps=2.16e-06 m=1
XN0 SCEb SCE VSS VSS sg13_hv_nmos w=0.550u l=0.450u ng=1 ad=1.87e-13 as=1.87e-13 pd=1.78e-06 ps=1.78e-06 m=1
XN4 net63 SCE VSS VSS sg13_hv_nmos w=0.740u l=0.450u ng=1 ad=2.516e-13 as=2.516e-13 pd=2.16e-06 ps=2.16e-06 m=1
XN2 net65 SCEb VSS VSS sg13_hv_nmos w=0.740u l=0.450u ng=1 ad=2.516e-13 as=2.516e-13 pd=2.16e-06 ps=2.16e-06 m=1
XN5 Dbb Db VSS VSS sg13_hv_nmos w=0.740u l=0.450u ng=1 ad=2.516e-13 as=2.516e-13 pd=2.16e-06 ps=2.16e-06 m=1
XN17 net12 net2 VSS VSS sg13_hv_nmos w=0.420u l=0.450u ng=1 ad=1.428e-13 as=1.428e-13 pd=1.52e-06 ps=1.52e-06 m=1
XN16 net5 clkneg net12 VSS sg13_hv_nmos w=0.420u l=0.450u ng=1 ad=1.428e-13 as=1.428e-13 pd=1.52e-06 ps=1.52e-06 m=1
XN18 net2 net5 net11 VSS sg13_hv_nmos w=0.420u l=0.450u ng=1 ad=1.428e-13 as=1.428e-13 pd=1.52e-06 ps=1.52e-06 m=1
XN19 net11 RESET_B VSS VSS sg13_hv_nmos w=0.420u l=0.450u ng=1 ad=1.428e-13 as=1.428e-13 pd=1.52e-06 ps=1.52e-06 m=1
XN20 Q net2 VSS VSS sg13_hv_nmos w=1.480u l=0.450u ng=2 ad=2.812e-13 as=5.032e-13 pd=2.24e-06 ps=4.32e-06 m=1
XN6 Dbbb Dbb net10 VSS sg13_hv_nmos w=0.420u l=0.450u ng=1 ad=1.428e-13 as=1.428e-13 pd=1.52e-06 ps=1.52e-06 m=1
XN7 net10 RESET_B VSS VSS sg13_hv_nmos w=0.420u l=0.450u ng=1 ad=1.428e-13 as=1.428e-13 pd=1.52e-06 ps=1.52e-06 m=1
XN10 Dbbb clkneg net6 VSS sg13_hv_nmos w=0.420u l=0.450u ng=1 ad=1.428e-13 as=1.428e-13 pd=1.52e-06 ps=1.52e-06 m=1
XN11 net6 clkpos net9 VSS sg13_hv_nmos w=0.420u l=0.450u ng=1 ad=1.428e-13 as=1.428e-13 pd=1.52e-06 ps=1.52e-06 m=1
XN12 net9 net4 net8 VSS sg13_hv_nmos w=0.420u l=0.450u ng=1 ad=1.428e-13 as=1.428e-13 pd=1.52e-06 ps=1.52e-06 m=1
XN13 net8 RESET_B VSS VSS sg13_hv_nmos w=0.420u l=0.450u ng=1 ad=1.428e-13 as=1.428e-13 pd=1.52e-06 ps=1.52e-06 m=1
XN14 net4 net6 VSS VSS sg13_hv_nmos w=0.740u l=0.450u ng=1 ad=2.516e-13 as=2.516e-13 pd=2.16e-06 ps=2.16e-06 m=1
XN8 clkneg CLK VSS VSS sg13_hv_nmos w=0.740u l=0.450u ng=1 ad=2.516e-13 as=2.516e-13 pd=2.16e-06 ps=2.16e-06 m=1
XN15 net4 clkpos net5 VSS sg13_hv_nmos w=0.740u l=0.450u ng=1 ad=2.516e-13 as=2.516e-13 pd=2.16e-06 ps=2.16e-06 m=1
XN9 clkpos clkneg VSS VSS sg13_hv_nmos w=0.740u l=0.450u ng=1 ad=2.516e-13 as=2.516e-13 pd=2.16e-06 ps=2.16e-06 m=1
XP1 net64 SCE VDD VDD sg13_hv_pmos w=2.400u l=0.450u ng=1 ad=8.16e-13 as=8.16e-13 pd=5.48e-06 ps=5.48e-06 m=1
XP3 net62 SCEb VDD VDD sg13_hv_pmos w=2.400u l=0.450u ng=1 ad=8.16e-13 as=8.16e-13 pd=5.48e-06 ps=5.48e-06 m=1
XP0 SCEb SCE VDD VDD sg13_hv_pmos w=2.015u l=0.450u ng=1 ad=6.851e-13 as=6.851e-13 pd=4.71e-06 ps=4.71e-06 m=1
XP4 Db SCD net62 VDD sg13_hv_pmos w=2.400u l=0.450u ng=1 ad=8.16e-13 as=8.16e-13 pd=5.48e-06 ps=5.48e-06 m=1
XP2 Db D net64 VDD sg13_hv_pmos w=2.400u l=0.450u ng=1 ad=8.16e-13 as=8.16e-13 pd=5.48e-06 ps=5.48e-06 m=1
XP5 Dbb Db VDD VDD sg13_hv_pmos w=2.690u l=0.450u ng=1 ad=9.146e-13 as=9.146e-13 pd=6.06e-06 ps=6.06e-06 m=1
XP17 net5 clkpos net3 VDD sg13_hv_pmos w=1.010u l=0.450u ng=1 ad=3.434e-13 as=3.434e-13 pd=2.7e-06 ps=2.7e-06 m=1
XP18 net2 net5 VDD VDD sg13_hv_pmos w=1.010u l=0.450u ng=1 ad=3.434e-13 as=3.434e-13 pd=2.7e-06 ps=2.7e-06 m=1
XP19 net2 RESET_B VDD VDD sg13_hv_pmos w=1.010u l=0.450u ng=1 ad=3.434e-13 as=3.434e-13 pd=2.7e-06 ps=2.7e-06 m=1
XP20 Q net2 VDD VDD sg13_hv_pmos w=5.380u l=0.450u ng=2 ad=1.0222e-12 as=1.8292e-12 pd=6.14e-06 ps=1.212e-05 m=1
XP10 Dbbb clkpos net6 VDD sg13_hv_pmos w=1.010u l=0.450u ng=1 ad=3.434e-13 as=3.434e-13 pd=2.7e-06 ps=2.7e-06 m=1
XP6 Dbbb RESET_B VDD VDD sg13_hv_pmos w=1.010u l=0.450u ng=1 ad=3.434e-13 as=3.434e-13 pd=2.7e-06 ps=2.7e-06 m=1
XP7 Dbbb Dbb VDD VDD sg13_hv_pmos w=1.010u l=0.450u ng=1 ad=3.434e-13 as=3.434e-13 pd=2.7e-06 ps=2.7e-06 m=1
XP11 net7 net4 VDD VDD sg13_hv_pmos w=1.010u l=0.450u ng=1 ad=3.434e-13 as=3.434e-13 pd=2.7e-06 ps=2.7e-06 m=1
XP12 net6 clkneg net7 VDD sg13_hv_pmos w=1.010u l=0.450u ng=1 ad=3.434e-13 as=3.434e-13 pd=2.7e-06 ps=2.7e-06 m=1
XP13 net6 RESET_B VDD VDD sg13_hv_pmos w=1.010u l=0.450u ng=1 ad=3.434e-13 as=3.434e-13 pd=2.7e-06 ps=2.7e-06 m=1
XP8 clkneg CLK VDD VDD sg13_hv_pmos w=2.690u l=0.450u ng=1 ad=9.146e-13 as=9.146e-13 pd=6.06e-06 ps=6.06e-06 m=1
XP9 clkpos clkneg VDD VDD sg13_hv_pmos w=2.690u l=0.450u ng=1 ad=9.146e-13 as=9.146e-13 pd=6.06e-06 ps=6.06e-06 m=1
XP14 net4 net6 VDD VDD sg13_hv_pmos w=2.400u l=0.450u ng=1 ad=8.16e-13 as=8.16e-13 pd=5.48e-06 ps=5.48e-06 m=1
XP15 net4 clkneg net5 VDD sg13_hv_pmos w=2.400u l=0.450u ng=1 ad=8.16e-13 as=8.16e-13 pd=5.48e-06 ps=5.48e-06 m=1
XP16 net3 net2 VDD VDD sg13_hv_pmos w=1.010u l=0.450u ng=1 ad=3.434e-13 as=3.434e-13 pd=2.7e-06 ps=2.7e-06 m=1
.ends
* End of subcircuit definition.

* Library name: sg13g2_stdcell_hv
* Cell name: sg13g2_hv_sdfrbp_2
* View name: schematic
.subckt sg13g2_hv_sdfrbp_2 Q Q_N CLK D RESET_B SCD SCE VDD VSS
XN3 Db SCD net63 VSS sg13_hv_nmos w=0.740u l=0.450u ng=1 ad=2.516e-13 as=2.516e-13 pd=2.16e-06 ps=2.16e-06 m=1
XN1 Db D net65 VSS sg13_hv_nmos w=0.740u l=0.450u ng=1 ad=2.516e-13 as=2.516e-13 pd=2.16e-06 ps=2.16e-06 m=1
XN0 SCEb SCE VSS VSS sg13_hv_nmos w=0.550u l=0.450u ng=1 ad=1.87e-13 as=1.87e-13 pd=1.78e-06 ps=1.78e-06 m=1
XN4 net63 SCE VSS VSS sg13_hv_nmos w=0.740u l=0.450u ng=1 ad=2.516e-13 as=2.516e-13 pd=2.16e-06 ps=2.16e-06 m=1
XN2 net65 SCEb VSS VSS sg13_hv_nmos w=0.740u l=0.450u ng=1 ad=2.516e-13 as=2.516e-13 pd=2.16e-06 ps=2.16e-06 m=1
XN5 Dbb Db VSS VSS sg13_hv_nmos w=0.740u l=0.450u ng=1 ad=2.516e-13 as=2.516e-13 pd=2.16e-06 ps=2.16e-06 m=1
XN17 net12 net2 VSS VSS sg13_hv_nmos w=0.420u l=0.450u ng=1 ad=1.428e-13 as=1.428e-13 pd=1.52e-06 ps=1.52e-06 m=1
XN16 net5 clkneg net12 VSS sg13_hv_nmos w=0.420u l=0.450u ng=1 ad=1.428e-13 as=1.428e-13 pd=1.52e-06 ps=1.52e-06 m=1
XN18 net2 net5 net11 VSS sg13_hv_nmos w=0.420u l=0.450u ng=1 ad=1.428e-13 as=1.428e-13 pd=1.52e-06 ps=1.52e-06 m=1
XN19 net11 RESET_B VSS VSS sg13_hv_nmos w=0.420u l=0.450u ng=1 ad=1.428e-13 as=1.428e-13 pd=1.52e-06 ps=1.52e-06 m=1
XN20 Q_N net5 VSS VSS sg13_hv_nmos w=1.480u l=0.450u ng=2 ad=2.812e-13 as=5.032e-13 pd=2.24e-06 ps=4.32e-06 m=1
XN6 Dbbb Dbb net10 VSS sg13_hv_nmos w=0.420u l=0.450u ng=1 ad=1.428e-13 as=1.428e-13 pd=1.52e-06 ps=1.52e-06 m=1
XN7 net10 RESET_B VSS VSS sg13_hv_nmos w=0.420u l=0.450u ng=1 ad=1.428e-13 as=1.428e-13 pd=1.52e-06 ps=1.52e-06 m=1
XN10 Dbbb clkneg net6 VSS sg13_hv_nmos w=0.420u l=0.450u ng=1 ad=1.428e-13 as=1.428e-13 pd=1.52e-06 ps=1.52e-06 m=1
XN11 net6 clkpos net9 VSS sg13_hv_nmos w=0.420u l=0.450u ng=1 ad=1.428e-13 as=1.428e-13 pd=1.52e-06 ps=1.52e-06 m=1
XN12 net9 net4 net8 VSS sg13_hv_nmos w=0.420u l=0.450u ng=1 ad=1.428e-13 as=1.428e-13 pd=1.52e-06 ps=1.52e-06 m=1
XN13 net8 RESET_B VSS VSS sg13_hv_nmos w=0.420u l=0.450u ng=1 ad=1.428e-13 as=1.428e-13 pd=1.52e-06 ps=1.52e-06 m=1
XN14 net4 net6 VSS VSS sg13_hv_nmos w=0.740u l=0.450u ng=1 ad=2.516e-13 as=2.516e-13 pd=2.16e-06 ps=2.16e-06 m=1
XN8 clkneg CLK VSS VSS sg13_hv_nmos w=0.740u l=0.450u ng=1 ad=2.516e-13 as=2.516e-13 pd=2.16e-06 ps=2.16e-06 m=1
XN15 net4 clkpos net5 VSS sg13_hv_nmos w=0.740u l=0.450u ng=1 ad=2.516e-13 as=2.516e-13 pd=2.16e-06 ps=2.16e-06 m=1
XN9 clkpos clkneg VSS VSS sg13_hv_nmos w=0.740u l=0.450u ng=1 ad=2.516e-13 as=2.516e-13 pd=2.16e-06 ps=2.16e-06 m=1
XN22 Q net1 VSS VSS sg13_hv_nmos w=1.480u l=0.450u ng=2 ad=2.812e-13 as=5.032e-13 pd=2.24e-06 ps=4.32e-06 m=1
XN21 net1 net5 VSS VSS sg13_hv_nmos w=0.640u l=0.450u ng=1 ad=2.176e-13 as=2.176e-13 pd=1.96e-06 ps=1.96e-06 m=1
XP1 net64 SCE VDD VDD sg13_hv_pmos w=2.400u l=0.450u ng=1 ad=8.16e-13 as=8.16e-13 pd=5.48e-06 ps=5.48e-06 m=1
XP3 net62 SCEb VDD VDD sg13_hv_pmos w=2.400u l=0.450u ng=1 ad=8.16e-13 as=8.16e-13 pd=5.48e-06 ps=5.48e-06 m=1
XP0 SCEb SCE VDD VDD sg13_hv_pmos w=2.015u l=0.450u ng=1 ad=6.851e-13 as=6.851e-13 pd=4.71e-06 ps=4.71e-06 m=1
XP4 Db SCD net62 VDD sg13_hv_pmos w=2.400u l=0.450u ng=1 ad=8.16e-13 as=8.16e-13 pd=5.48e-06 ps=5.48e-06 m=1
XP2 Db D net64 VDD sg13_hv_pmos w=2.400u l=0.450u ng=1 ad=8.16e-13 as=8.16e-13 pd=5.48e-06 ps=5.48e-06 m=1
XP5 Dbb Db VDD VDD sg13_hv_pmos w=2.690u l=0.450u ng=1 ad=9.146e-13 as=9.146e-13 pd=6.06e-06 ps=6.06e-06 m=1
XP17 net5 clkpos net3 VDD sg13_hv_pmos w=1.010u l=0.450u ng=1 ad=3.434e-13 as=3.434e-13 pd=2.7e-06 ps=2.7e-06 m=1
XP18 net2 net5 VDD VDD sg13_hv_pmos w=1.010u l=0.450u ng=1 ad=3.434e-13 as=3.434e-13 pd=2.7e-06 ps=2.7e-06 m=1
XP19 net2 RESET_B VDD VDD sg13_hv_pmos w=1.010u l=0.450u ng=1 ad=3.434e-13 as=3.434e-13 pd=2.7e-06 ps=2.7e-06 m=1
XP20 Q_N net5 VDD VDD sg13_hv_pmos w=5.380u l=0.450u ng=2 ad=1.0222e-12 as=1.8292e-12 pd=6.14e-06 ps=1.212e-05 m=1
XP10 Dbbb clkpos net6 VDD sg13_hv_pmos w=1.010u l=0.450u ng=1 ad=3.434e-13 as=3.434e-13 pd=2.7e-06 ps=2.7e-06 m=1
XP6 Dbbb RESET_B VDD VDD sg13_hv_pmos w=1.010u l=0.450u ng=1 ad=3.434e-13 as=3.434e-13 pd=2.7e-06 ps=2.7e-06 m=1
XP7 Dbbb Dbb VDD VDD sg13_hv_pmos w=1.010u l=0.450u ng=1 ad=3.434e-13 as=3.434e-13 pd=2.7e-06 ps=2.7e-06 m=1
XP11 net7 net4 VDD VDD sg13_hv_pmos w=1.010u l=0.450u ng=1 ad=3.434e-13 as=3.434e-13 pd=2.7e-06 ps=2.7e-06 m=1
XP12 net6 clkneg net7 VDD sg13_hv_pmos w=1.010u l=0.450u ng=1 ad=3.434e-13 as=3.434e-13 pd=2.7e-06 ps=2.7e-06 m=1
XP13 net6 RESET_B VDD VDD sg13_hv_pmos w=1.010u l=0.450u ng=1 ad=3.434e-13 as=3.434e-13 pd=2.7e-06 ps=2.7e-06 m=1
XP8 clkneg CLK VDD VDD sg13_hv_pmos w=2.690u l=0.450u ng=1 ad=9.146e-13 as=9.146e-13 pd=6.06e-06 ps=6.06e-06 m=1
XP9 clkpos clkneg VDD VDD sg13_hv_pmos w=2.690u l=0.450u ng=1 ad=9.146e-13 as=9.146e-13 pd=6.06e-06 ps=6.06e-06 m=1
XP14 net4 net6 VDD VDD sg13_hv_pmos w=2.400u l=0.450u ng=1 ad=8.16e-13 as=8.16e-13 pd=5.48e-06 ps=5.48e-06 m=1
XP15 net4 clkneg net5 VDD sg13_hv_pmos w=2.400u l=0.450u ng=1 ad=8.16e-13 as=8.16e-13 pd=5.48e-06 ps=5.48e-06 m=1
XP22 Q net1 VDD VDD sg13_hv_pmos w=5.380u l=0.450u ng=2 ad=1.0222e-12 as=1.8292e-12 pd=6.14e-06 ps=1.212e-05 m=1
XP16 net3 net2 VDD VDD sg13_hv_pmos w=1.010u l=0.450u ng=1 ad=3.434e-13 as=3.434e-13 pd=2.7e-06 ps=2.7e-06 m=1
XP21 net1 net5 VDD VDD sg13_hv_pmos w=2.400u l=0.450u ng=1 ad=8.16e-13 as=8.16e-13 pd=5.48e-06 ps=5.48e-06 m=1
.ends
* End of subcircuit definition.

* Library name: sg13g2_stdcell_hv
* Cell name: sg13g2_hv_sdfrbp_1
* View name: schematic
.subckt sg13g2_hv_sdfrbp_1 Q Q_N CLK D RESET_B SCD SCE VDD VSS
XN3 Db SCD net63 VSS sg13_hv_nmos w=0.740u l=0.450u ng=1 ad=2.516e-13 as=2.516e-13 pd=2.16e-06 ps=2.16e-06 m=1
XN1 Db D net65 VSS sg13_hv_nmos w=0.740u l=0.450u ng=1 ad=2.516e-13 as=2.516e-13 pd=2.16e-06 ps=2.16e-06 m=1
XN0 SCEb SCE VSS VSS sg13_hv_nmos w=0.550u l=0.450u ng=1 ad=1.87e-13 as=1.87e-13 pd=1.78e-06 ps=1.78e-06 m=1
XN4 net63 SCE VSS VSS sg13_hv_nmos w=0.740u l=0.450u ng=1 ad=2.516e-13 as=2.516e-13 pd=2.16e-06 ps=2.16e-06 m=1
XN2 net65 SCEb VSS VSS sg13_hv_nmos w=0.740u l=0.450u ng=1 ad=2.516e-13 as=2.516e-13 pd=2.16e-06 ps=2.16e-06 m=1
XN5 net13 Db VSS VSS sg13_hv_nmos w=0.740u l=0.450u ng=1 ad=2.516e-13 as=2.516e-13 pd=2.16e-06 ps=2.16e-06 m=1
XN17 net12 net2 VSS VSS sg13_hv_nmos w=0.420u l=0.450u ng=1 ad=1.428e-13 as=1.428e-13 pd=1.52e-06 ps=1.52e-06 m=1
XN16 net5 clkneg net12 VSS sg13_hv_nmos w=0.420u l=0.450u ng=1 ad=1.428e-13 as=1.428e-13 pd=1.52e-06 ps=1.52e-06 m=1
XN18 net2 net5 net11 VSS sg13_hv_nmos w=0.420u l=0.450u ng=1 ad=1.428e-13 as=1.428e-13 pd=1.52e-06 ps=1.52e-06 m=1
XN19 net11 RESET_B VSS VSS sg13_hv_nmos w=0.420u l=0.450u ng=1 ad=1.428e-13 as=1.428e-13 pd=1.52e-06 ps=1.52e-06 m=1
XN20 Q_N net5 VSS VSS sg13_hv_nmos w=0.740u l=0.450u ng=1 ad=2.516e-13 as=2.516e-13 pd=2.16e-06 ps=2.16e-06 m=1
XN6 Dbb net13 net10 VSS sg13_hv_nmos w=0.420u l=0.450u ng=1 ad=1.428e-13 as=1.428e-13 pd=1.52e-06 ps=1.52e-06 m=1
XN7 net10 RESET_B VSS VSS sg13_hv_nmos w=0.420u l=0.450u ng=1 ad=1.428e-13 as=1.428e-13 pd=1.52e-06 ps=1.52e-06 m=1
XN10 Dbb clkneg net6 VSS sg13_hv_nmos w=0.420u l=0.450u ng=1 ad=1.428e-13 as=1.428e-13 pd=1.52e-06 ps=1.52e-06 m=1
XN11 net6 clkpos net9 VSS sg13_hv_nmos w=0.420u l=0.450u ng=1 ad=1.428e-13 as=1.428e-13 pd=1.52e-06 ps=1.52e-06 m=1
XN12 net9 net4 net8 VSS sg13_hv_nmos w=0.420u l=0.450u ng=1 ad=1.428e-13 as=1.428e-13 pd=1.52e-06 ps=1.52e-06 m=1
XN13 net8 RESET_B VSS VSS sg13_hv_nmos w=0.420u l=0.450u ng=1 ad=1.428e-13 as=1.428e-13 pd=1.52e-06 ps=1.52e-06 m=1
XN14 net4 net6 VSS VSS sg13_hv_nmos w=0.740u l=0.450u ng=1 ad=2.516e-13 as=2.516e-13 pd=2.16e-06 ps=2.16e-06 m=1
XN8 clkneg CLK VSS VSS sg13_hv_nmos w=0.740u l=0.450u ng=1 ad=2.516e-13 as=2.516e-13 pd=2.16e-06 ps=2.16e-06 m=1
XN15 net4 clkpos net5 VSS sg13_hv_nmos w=0.740u l=0.450u ng=1 ad=2.516e-13 as=2.516e-13 pd=2.16e-06 ps=2.16e-06 m=1
XN9 clkpos clkneg VSS VSS sg13_hv_nmos w=0.740u l=0.450u ng=1 ad=2.516e-13 as=2.516e-13 pd=2.16e-06 ps=2.16e-06 m=1
XN22 Q net1 VSS VSS sg13_hv_nmos w=0.740u l=0.450u ng=1 ad=2.516e-13 as=2.516e-13 pd=2.16e-06 ps=2.16e-06 m=1
XN21 net1 net5 VSS VSS sg13_hv_nmos w=0.640u l=0.450u ng=1 ad=2.176e-13 as=2.176e-13 pd=1.96e-06 ps=1.96e-06 m=1
XP1 net64 SCE VDD VDD sg13_hv_pmos w=2.400u l=0.450u ng=1 ad=8.16e-13 as=8.16e-13 pd=5.48e-06 ps=5.48e-06 m=1
XP3 net62 SCEb VDD VDD sg13_hv_pmos w=2.400u l=0.450u ng=1 ad=8.16e-13 as=8.16e-13 pd=5.48e-06 ps=5.48e-06 m=1
XP0 SCEb SCE VDD VDD sg13_hv_pmos w=2.015u l=0.450u ng=1 ad=6.851e-13 as=6.851e-13 pd=4.71e-06 ps=4.71e-06 m=1
XP4 Db SCD net62 VDD sg13_hv_pmos w=2.400u l=0.450u ng=1 ad=8.16e-13 as=8.16e-13 pd=5.48e-06 ps=5.48e-06 m=1
XP2 Db D net64 VDD sg13_hv_pmos w=2.400u l=0.450u ng=1 ad=8.16e-13 as=8.16e-13 pd=5.48e-06 ps=5.48e-06 m=1
XP5 net13 Db VDD VDD sg13_hv_pmos w=2.690u l=0.450u ng=1 ad=9.146e-13 as=9.146e-13 pd=6.06e-06 ps=6.06e-06 m=1
XP17 net5 clkpos net3 VDD sg13_hv_pmos w=1.010u l=0.450u ng=1 ad=3.434e-13 as=3.434e-13 pd=2.7e-06 ps=2.7e-06 m=1
XP18 net2 net5 VDD VDD sg13_hv_pmos w=1.010u l=0.450u ng=1 ad=3.434e-13 as=3.434e-13 pd=2.7e-06 ps=2.7e-06 m=1
XP19 net2 RESET_B VDD VDD sg13_hv_pmos w=1.010u l=0.450u ng=1 ad=3.434e-13 as=3.434e-13 pd=2.7e-06 ps=2.7e-06 m=1
XP20 Q_N net5 VDD VDD sg13_hv_pmos w=2.690u l=0.450u ng=1 ad=9.146e-13 as=9.146e-13 pd=6.06e-06 ps=6.06e-06 m=1
XP10 Dbb clkpos net6 VDD sg13_hv_pmos w=1.010u l=0.450u ng=1 ad=3.434e-13 as=3.434e-13 pd=2.7e-06 ps=2.7e-06 m=1
XP6 Dbb RESET_B VDD VDD sg13_hv_pmos w=1.010u l=0.450u ng=1 ad=3.434e-13 as=3.434e-13 pd=2.7e-06 ps=2.7e-06 m=1
XP7 Dbb net13 VDD VDD sg13_hv_pmos w=1.010u l=0.450u ng=1 ad=3.434e-13 as=3.434e-13 pd=2.7e-06 ps=2.7e-06 m=1
XP11 net7 net4 VDD VDD sg13_hv_pmos w=1.010u l=0.450u ng=1 ad=3.434e-13 as=3.434e-13 pd=2.7e-06 ps=2.7e-06 m=1
XP12 net6 clkneg net7 VDD sg13_hv_pmos w=1.010u l=0.450u ng=1 ad=3.434e-13 as=3.434e-13 pd=2.7e-06 ps=2.7e-06 m=1
XP13 net6 RESET_B VDD VDD sg13_hv_pmos w=1.010u l=0.450u ng=1 ad=3.434e-13 as=3.434e-13 pd=2.7e-06 ps=2.7e-06 m=1
XP8 clkneg CLK VDD VDD sg13_hv_pmos w=2.690u l=0.450u ng=1 ad=9.146e-13 as=9.146e-13 pd=6.06e-06 ps=6.06e-06 m=1
XP9 clkpos clkneg VDD VDD sg13_hv_pmos w=2.690u l=0.450u ng=1 ad=9.146e-13 as=9.146e-13 pd=6.06e-06 ps=6.06e-06 m=1
XP14 net4 net6 VDD VDD sg13_hv_pmos w=2.400u l=0.450u ng=1 ad=8.16e-13 as=8.16e-13 pd=5.48e-06 ps=5.48e-06 m=1
XP15 net4 clkneg net5 VDD sg13_hv_pmos w=2.400u l=0.450u ng=1 ad=8.16e-13 as=8.16e-13 pd=5.48e-06 ps=5.48e-06 m=1
XP22 Q net1 VDD VDD sg13_hv_pmos w=2.690u l=0.450u ng=1 ad=9.146e-13 as=9.146e-13 pd=6.06e-06 ps=6.06e-06 m=1
XP16 net3 net2 VDD VDD sg13_hv_pmos w=1.010u l=0.450u ng=1 ad=3.434e-13 as=3.434e-13 pd=2.7e-06 ps=2.7e-06 m=1
XP21 net1 net5 VDD VDD sg13_hv_pmos w=2.400u l=0.450u ng=1 ad=8.16e-13 as=8.16e-13 pd=5.48e-06 ps=5.48e-06 m=1
.ends
* End of subcircuit definition.

* Library name: sg13g2_stdcell_hv
* Cell name: sg13g2_hv_dfrbpq_2
* View name: schematic
.subckt sg13g2_hv_dfrbpq_2 Q CLK D RESET_B VDD VSS
XN11 net12 net2 VSS VSS sg13_hv_nmos w=0.420u l=0.450u ng=1 ad=1.428e-13 as=1.428e-13 pd=1.52e-06 ps=1.52e-06 m=1
XN10 net5 clkneg net12 VSS sg13_hv_nmos w=0.420u l=0.450u ng=1 ad=1.428e-13 as=1.428e-13 pd=1.52e-06 ps=1.52e-06 m=1
XN12 net2 net5 net11 VSS sg13_hv_nmos w=0.420u l=0.450u ng=1 ad=1.428e-13 as=1.428e-13 pd=1.52e-06 ps=1.52e-06 m=1
XN13 net11 RESET_B VSS VSS sg13_hv_nmos w=0.420u l=0.450u ng=1 ad=1.428e-13 as=1.428e-13 pd=1.52e-06 ps=1.52e-06 m=1
XN0 Db D net10 VSS sg13_hv_nmos w=0.420u l=0.450u ng=1 ad=1.428e-13 as=1.428e-13 pd=1.52e-06 ps=1.52e-06 m=1
XN1 net10 RESET_B VSS VSS sg13_hv_nmos w=0.420u l=0.450u ng=1 ad=1.428e-13 as=1.428e-13 pd=1.52e-06 ps=1.52e-06 m=1
XN4 Db clkneg net6 VSS sg13_hv_nmos w=0.420u l=0.450u ng=1 ad=1.428e-13 as=1.428e-13 pd=1.52e-06 ps=1.52e-06 m=1
XN5 net6 clkpos net9 VSS sg13_hv_nmos w=0.420u l=0.450u ng=1 ad=1.428e-13 as=1.428e-13 pd=1.52e-06 ps=1.52e-06 m=1
XN6 net9 net4 net8 VSS sg13_hv_nmos w=0.420u l=0.450u ng=1 ad=1.428e-13 as=1.428e-13 pd=1.52e-06 ps=1.52e-06 m=1
XN7 net8 RESET_B VSS VSS sg13_hv_nmos w=0.420u l=0.450u ng=1 ad=1.428e-13 as=1.428e-13 pd=1.52e-06 ps=1.52e-06 m=1
XN8 net4 net6 VSS VSS sg13_hv_nmos w=0.740u l=0.450u ng=1 ad=2.516e-13 as=2.516e-13 pd=2.16e-06 ps=2.16e-06 m=1
XN2 clkneg CLK VSS VSS sg13_hv_nmos w=0.740u l=0.450u ng=1 ad=2.516e-13 as=2.516e-13 pd=2.16e-06 ps=2.16e-06 m=1
XN9 net4 clkpos net5 VSS sg13_hv_nmos w=0.740u l=0.450u ng=1 ad=2.516e-13 as=2.516e-13 pd=2.16e-06 ps=2.16e-06 m=1
XN3 clkpos clkneg VSS VSS sg13_hv_nmos w=0.740u l=0.450u ng=1 ad=2.516e-13 as=2.516e-13 pd=2.16e-06 ps=2.16e-06 m=1
XN15 Q net1 VSS VSS sg13_hv_nmos w=1.480u l=0.450u ng=2 ad=2.812e-13 as=5.032e-13 pd=2.24e-06 ps=4.32e-06 m=1
XN14 net1 net5 VSS VSS sg13_hv_nmos w=0.640u l=0.450u ng=1 ad=2.176e-13 as=2.176e-13 pd=1.96e-06 ps=1.96e-06 m=1
XP11 net5 clkpos net3 VDD sg13_hv_pmos w=1.010u l=0.450u ng=1 ad=3.434e-13 as=3.434e-13 pd=2.7e-06 ps=2.7e-06 m=1
XP12 net2 net5 VDD VDD sg13_hv_pmos w=1.010u l=0.450u ng=1 ad=3.434e-13 as=3.434e-13 pd=2.7e-06 ps=2.7e-06 m=1
XP13 net2 RESET_B VDD VDD sg13_hv_pmos w=1.010u l=0.450u ng=1 ad=3.434e-13 as=3.434e-13 pd=2.7e-06 ps=2.7e-06 m=1
XP4 Db clkpos net6 VDD sg13_hv_pmos w=1.010u l=0.450u ng=1 ad=3.434e-13 as=3.434e-13 pd=2.7e-06 ps=2.7e-06 m=1
XP0 Db RESET_B VDD VDD sg13_hv_pmos w=1.010u l=0.450u ng=1 ad=3.434e-13 as=3.434e-13 pd=2.7e-06 ps=2.7e-06 m=1
XP1 Db D VDD VDD sg13_hv_pmos w=1.010u l=0.450u ng=1 ad=3.434e-13 as=3.434e-13 pd=2.7e-06 ps=2.7e-06 m=1
XP5 net7 net4 VDD VDD sg13_hv_pmos w=1.010u l=0.450u ng=1 ad=3.434e-13 as=3.434e-13 pd=2.7e-06 ps=2.7e-06 m=1
XP6 net6 clkneg net7 VDD sg13_hv_pmos w=1.010u l=0.450u ng=1 ad=3.434e-13 as=3.434e-13 pd=2.7e-06 ps=2.7e-06 m=1
XP7 net6 RESET_B VDD VDD sg13_hv_pmos w=1.010u l=0.450u ng=1 ad=3.434e-13 as=3.434e-13 pd=2.7e-06 ps=2.7e-06 m=1
XP2 clkneg CLK VDD VDD sg13_hv_pmos w=2.690u l=0.450u ng=1 ad=9.146e-13 as=9.146e-13 pd=6.06e-06 ps=6.06e-06 m=1
XP3 clkpos clkneg VDD VDD sg13_hv_pmos w=2.690u l=0.450u ng=1 ad=9.146e-13 as=9.146e-13 pd=6.06e-06 ps=6.06e-06 m=1
XP8 net4 net6 VDD VDD sg13_hv_pmos w=2.400u l=0.450u ng=1 ad=8.16e-13 as=8.16e-13 pd=5.48e-06 ps=5.48e-06 m=1
XP9 net4 clkneg net5 VDD sg13_hv_pmos w=2.400u l=0.450u ng=1 ad=8.16e-13 as=8.16e-13 pd=5.48e-06 ps=5.48e-06 m=1
XP15 Q net1 VDD VDD sg13_hv_pmos w=5.380u l=0.450u ng=2 ad=1.0222e-12 as=1.8292e-12 pd=6.14e-06 ps=1.212e-05 m=1
XP10 net3 net2 VDD VDD sg13_hv_pmos w=1.010u l=0.450u ng=1 ad=3.434e-13 as=3.434e-13 pd=2.7e-06 ps=2.7e-06 m=1
XP14 net1 net5 VDD VDD sg13_hv_pmos w=2.400u l=0.450u ng=1 ad=8.16e-13 as=8.16e-13 pd=5.48e-06 ps=5.48e-06 m=1
.ends
* End of subcircuit definition.

* Library name: sg13g2_stdcell_hv
* Cell name: sg13g2_hv_dfrbpq_1
* View name: schematic
.subckt sg13g2_hv_dfrbpq_1 Q CLK D RESET_B VDD VSS
XN11 net12 net2 VSS VSS sg13_hv_nmos w=0.420u l=0.450u ng=1 ad=1.428e-13 as=1.428e-13 pd=1.52e-06 ps=1.52e-06 m=1
XN10 net5 clkneg net12 VSS sg13_hv_nmos w=0.420u l=0.450u ng=1 ad=1.428e-13 as=1.428e-13 pd=1.52e-06 ps=1.52e-06 m=1
XN12 net2 net5 net11 VSS sg13_hv_nmos w=0.420u l=0.450u ng=1 ad=1.428e-13 as=1.428e-13 pd=1.52e-06 ps=1.52e-06 m=1
XN13 net11 RESET_B VSS VSS sg13_hv_nmos w=0.420u l=0.450u ng=1 ad=1.428e-13 as=1.428e-13 pd=1.52e-06 ps=1.52e-06 m=1
XN0 Db D net10 VSS sg13_hv_nmos w=0.420u l=0.450u ng=1 ad=1.428e-13 as=1.428e-13 pd=1.52e-06 ps=1.52e-06 m=1
XN1 net10 RESET_B VSS VSS sg13_hv_nmos w=0.420u l=0.450u ng=1 ad=1.428e-13 as=1.428e-13 pd=1.52e-06 ps=1.52e-06 m=1
XN4 Db clkneg net6 VSS sg13_hv_nmos w=0.420u l=0.450u ng=1 ad=1.428e-13 as=1.428e-13 pd=1.52e-06 ps=1.52e-06 m=1
XN5 net6 clkpos net9 VSS sg13_hv_nmos w=0.420u l=0.450u ng=1 ad=1.428e-13 as=1.428e-13 pd=1.52e-06 ps=1.52e-06 m=1
XN6 net9 net4 net8 VSS sg13_hv_nmos w=0.420u l=0.450u ng=1 ad=1.428e-13 as=1.428e-13 pd=1.52e-06 ps=1.52e-06 m=1
XN7 net8 RESET_B VSS VSS sg13_hv_nmos w=0.420u l=0.450u ng=1 ad=1.428e-13 as=1.428e-13 pd=1.52e-06 ps=1.52e-06 m=1
XN8 net4 net6 VSS VSS sg13_hv_nmos w=0.740u l=0.450u ng=1 ad=2.516e-13 as=2.516e-13 pd=2.16e-06 ps=2.16e-06 m=1
XN2 clkneg CLK VSS VSS sg13_hv_nmos w=0.740u l=0.450u ng=1 ad=2.516e-13 as=2.516e-13 pd=2.16e-06 ps=2.16e-06 m=1
XN9 net4 clkpos net5 VSS sg13_hv_nmos w=0.740u l=0.450u ng=1 ad=2.516e-13 as=2.516e-13 pd=2.16e-06 ps=2.16e-06 m=1
XN3 clkpos clkneg VSS VSS sg13_hv_nmos w=0.740u l=0.450u ng=1 ad=2.516e-13 as=2.516e-13 pd=2.16e-06 ps=2.16e-06 m=1
XN15 Q net1 VSS VSS sg13_hv_nmos w=0.740u l=0.450u ng=1 ad=2.516e-13 as=2.516e-13 pd=2.16e-06 ps=2.16e-06 m=1
XN14 net1 net5 VSS VSS sg13_hv_nmos w=0.740u l=0.450u ng=1 ad=2.516e-13 as=2.516e-13 pd=2.16e-06 ps=2.16e-06 m=1
XP11 net5 clkpos net3 VDD sg13_hv_pmos w=1.010u l=0.450u ng=1 ad=3.434e-13 as=3.434e-13 pd=2.7e-06 ps=2.7e-06 m=1
XP12 net2 net5 VDD VDD sg13_hv_pmos w=1.010u l=0.450u ng=1 ad=3.434e-13 as=3.434e-13 pd=2.7e-06 ps=2.7e-06 m=1
XP13 net2 RESET_B VDD VDD sg13_hv_pmos w=1.010u l=0.450u ng=1 ad=3.434e-13 as=3.434e-13 pd=2.7e-06 ps=2.7e-06 m=1
XP4 Db clkpos net6 VDD sg13_hv_pmos w=1.010u l=0.450u ng=1 ad=3.434e-13 as=3.434e-13 pd=2.7e-06 ps=2.7e-06 m=1
XP0 Db RESET_B VDD VDD sg13_hv_pmos w=1.010u l=0.450u ng=1 ad=3.434e-13 as=3.434e-13 pd=2.7e-06 ps=2.7e-06 m=1
XP1 Db D VDD VDD sg13_hv_pmos w=1.010u l=0.450u ng=1 ad=3.434e-13 as=3.434e-13 pd=2.7e-06 ps=2.7e-06 m=1
XP5 net7 net4 VDD VDD sg13_hv_pmos w=1.010u l=0.450u ng=1 ad=3.434e-13 as=3.434e-13 pd=2.7e-06 ps=2.7e-06 m=1
XP6 net6 clkneg net7 VDD sg13_hv_pmos w=1.010u l=0.450u ng=1 ad=3.434e-13 as=3.434e-13 pd=2.7e-06 ps=2.7e-06 m=1
XP7 net6 RESET_B VDD VDD sg13_hv_pmos w=1.010u l=0.450u ng=1 ad=3.434e-13 as=3.434e-13 pd=2.7e-06 ps=2.7e-06 m=1
XP2 clkneg CLK VDD VDD sg13_hv_pmos w=2.690u l=0.450u ng=1 ad=9.146e-13 as=9.146e-13 pd=6.06e-06 ps=6.06e-06 m=1
XP3 clkpos clkneg VDD VDD sg13_hv_pmos w=2.690u l=0.450u ng=1 ad=9.146e-13 as=9.146e-13 pd=6.06e-06 ps=6.06e-06 m=1
XP8 net4 net6 VDD VDD sg13_hv_pmos w=2.400u l=0.450u ng=1 ad=8.16e-13 as=8.16e-13 pd=5.48e-06 ps=5.48e-06 m=1
XP9 net4 clkneg net5 VDD sg13_hv_pmos w=2.400u l=0.450u ng=1 ad=8.16e-13 as=8.16e-13 pd=5.48e-06 ps=5.48e-06 m=1
XP15 Q net1 VDD VDD sg13_hv_pmos w=2.690u l=0.450u ng=1 ad=9.146e-13 as=9.146e-13 pd=6.06e-06 ps=6.06e-06 m=1
XP10 net3 net2 VDD VDD sg13_hv_pmos w=1.010u l=0.450u ng=1 ad=3.434e-13 as=3.434e-13 pd=2.7e-06 ps=2.7e-06 m=1
XP14 net1 net5 VDD VDD sg13_hv_pmos w=2.690u l=0.450u ng=1 ad=9.146e-13 as=9.146e-13 pd=6.06e-06 ps=6.06e-06 m=1
.ends
* End of subcircuit definition.

* Library name: sg13g2_stdcell_hv
* Cell name: sg13g2_hv_fill_1
* View name: schematic
.subckt sg13g2_hv_fill_1 VDD VSS
.ends
* End of subcircuit definition.

* Library name: sg13g2_stdcell_hv
* Cell name: sg13g2_hv_fill_2
* View name: schematic
.subckt sg13g2_hv_fill_2 VDD VSS
.ends
* End of subcircuit definition.

* Library name: sg13g2_stdcell_hv
* Cell name: sg13g2_hv_fill_4
* View name: schematic
.subckt sg13g2_hv_fill_4 VDD VSS
.ends
* End of subcircuit definition.

* Library name: sg13g2_stdcell_hv
* Cell name: sg13g2_hv_fill_8
* View name: schematic
.subckt sg13g2_hv_fill_8 VDD VSS
.ends
* End of subcircuit definition.

.subckt sg13g2_hv_tielo L_LO VDD VSS
XN0 L_LO VDD VSS VSS sg13_hv_nmos w=0.740u l=0.450u ng=1 ad=2.516e-13 as=2.516e-13 pd=2.16e-06 ps=2.16e-06 m=1
XP0 L_LO VDD VDD VDD sg13_hv_pmos w=2.690u l=0.450u ng=1 ad=9.146e-13 as=9.146e-13 pd=6.06e-06 ps=6.06e-06 m=1
.ends

.subckt sg13g2_hv_tiehi L_HI VDD VSS
XN0 L_HI VSS VSS VSS sg13_hv_nmos w=0.740u l=0.450u ng=1 ad=2.516e-13 as=2.516e-13 pd=2.16e-06 ps=2.16e-06 m=1
XP0 L_HI VSS VDD VDD sg13_hv_pmos w=2.690u l=0.450u ng=1 ad=9.146e-13 as=9.146e-13 pd=6.06e-06 ps=6.06e-06 m=1
.ends
