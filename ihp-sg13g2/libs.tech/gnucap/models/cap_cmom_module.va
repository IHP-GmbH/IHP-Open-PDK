//******************************************************************************
//                                                                             *
// Copyright 2026 IHP PDK Authors                                              *
//                                                                             *
// Licensed under the Apache License, Version 2.0 (the "License");             *
// you may not use this file except in compliance with the License.            *
// You may obtain a copy of the License at                                     *
//                                                                             *
//     https://www.apache.org/licenses/LICENSE-2.0                             *
//                                                                             *
// Unless required by applicable law or agreed to in writing, software         *
// distributed under the License is distributed on an "AS IS" BASIS,           *
// WITHOUT WARRANTIES OR CONDITIONS OF ANY KIND, either express or implied.    *
// See the License for the specific language governing permissions and         *
// limitations under the License.                                              *
//                                                                             *
//******************************************************************************

// gnucap build unit for the interdigitated MoM capacitor.
//
// This is a build shim, not a paramset: cap_cmom is a single behavioural
// compact module (module cap_cmom(PLUS, MINUS, SUB)) with no corner/mismatch
// spread, so unlike cmim it does not decompose into an sp_capacitor primitive
// plus corner paramsets. The module itself lives in the shared Verilog-A
//
//     ../../verilog-a/cap_cmom/cap_cmom.va
//
// and is included below verbatim. Keeping a single source means the gnucap
// plugin and the ngspice OSDI build compile byte-for-byte identical model code.
// The include resolves through the Makefile MGFLAGS path
// -I ../../verilog-a/cap_cmom. gnucap-mg-vams elaborates the included module
// directly into the plugin (see `make dump-cap_cmom_module` for the emitted
// module cap_cmom(PLUS, MINUS, SUB) ... analog ... endmodule).
//
// Terminals: tie SUB to ground for the classic 2-terminal use, exactly as the
// ngspice wrapper subckt does.

`include "cap_cmom.va"
