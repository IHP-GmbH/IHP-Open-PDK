//******************************************************************************
//
// Copyright 2026 IHP PDK Authors
//
// Licensed under the Apache License, Version 2.0 (the "License");
// you may not use this file except in compliance with the License.
// You may obtain a copy of the License at
//
//     https://www.apache.org/licenses/LICENSE-2.0
//
// Unless required by applicable law or agreed to in writing, software
// distributed under the License is distributed on an "AS IS" BASIS,
// WITHOUT WARRANTIES OR CONDITIONS OF ANY KIND, either express or implied.
// See the License for the specific language governing permissions and
// limitations under the License.
//
//******************************************************************************

//******************************************************************************
//                                                                             *
//                                                                             *
//              C O M M O N    SG 13  C A P A C I T O R    M O D E L S         *
//                                                                             *
//                                                                             *
//******************************************************************************

//******************************************************************************
// Capacitor modules
//
// Adopted from ngspice/models/capacitors_*.lib
//
// Modifications:
// - removed sf scale factor
// - removed ic parameter TODO: is this ok?
// - moved if branches in cap_rfcmim into localparams
//******************************************************************************

// TODO: test setting multiplicity via $mfactor during device instantiaion

//******************************************************************************
// cmim
//******************************************************************************

// Note: top/bottom plate parasitic capacitance is included by parasiticC extraction!
// Note: top (Metal3) corresponds to PLUS pin

`include "disciplines.vams"

(* desc="cap_cmim capacitor module" *)
module cap_cmim(PLUS, MINUS);
    inout PLUS, MINUS;
    electrical PLUS, MINUS;

    electrical n1;

    (* desc="Device length", units="m" *)
    parameter real l = 7u from [7u:75u];
    (* desc="Device width", units="m" *)
    parameter real w = 7u from [7u:75u];
    (* desc="Enable mismatch" *)
    parameter integer mm_ok = 0 from [0:1];

    resistor #(.r(55m)) R1(PLUS, n1);
    cmim_core #(.l(l), .w(w), .mm_ok(mm_ok)) C1(n1, MINUS);
endmodule

//******************************************************************************
// rfcmim
//******************************************************************************

// module for rfcmim
// Note: top plate (Metal3) corresponds to PLUS pin, bottom plate corresponds to MINUS pin, bn is substrate bulk node
// Note: valid parameter range for w and l: 7um to 75um
// Note: valid parameter range for wfeed: 1um to 30um but maximum wfeed = w-1.2um

(* desc="cap_rfcmim capacitor module" *)
module cap_rfcmim(PLUS, MINUS, bn);
    inout PLUS, MINUS, bn;
    electrical PLUS, MINUS, bn;

    electrical n2, n3, n4, n5, n51;

    (* desc="Device length", units="m" *)
    parameter real l = 7u from [7u:75u];
    (* desc="Device width", units="m" *)
    parameter real w = 7u from [7u:75u];
    (* desc="Enable mismatch" *)
    parameter integer mm_ok = 0 from [0:1];
    (* desc="Feed line width", units="m" *)
    parameter real wfeed = 2u from [1u:30u];
    (* desc="Coupling capacitance to substrate", units="F" *)
    parameter real cic0 = 1E-18;

    localparam real sf = 1E-6;
    localparam real lplate_val = (0.353158 * (l/sf) + 0.485684*l/w) * 1e-12;
    localparam real lfeed_val  = (6.03468  + 0.0814268* (w/sf) - 0.821243*log(wfeed/sf)/log(1.55)) * 1e-12;
    localparam real lskin_val  = 1.18545e-012 + 6.95462e-014*(l/sf);
    localparam real cox_val    = (0.48922 + 0.0965145*(w+l)/sf + 0.00610947   * (w*l)/(sf*sf) + 0.017*(wfeed/sf)*5)*1e-15;
    localparam real csub_val   = (50.1021 + 0.277881 *(w+l)/sf + 1.25023e-005 * (w*l)/(sf*sf))*1e-15;
    localparam real rsub_val   = 610.132  - 1.11685  *(w+l)/sf + 0.00434371   * (w*l)/(sf*sf);
    localparam real rmim_val   = 0.0463973 + 0.00219577*l/w + 0.961292/(wfeed/sf) + 0.00307712 *(l/sf) + 0.000217076*(l/sf)*l/w;
    localparam real rskin_val  = 0.154618 + 0.00702016*(l/sf);
    localparam real lmim_raw = lplate_val + lfeed_val - lskin_val;
    localparam real lmim_eff = (lmim_raw > 1.0e-18) ? lmim_raw : 1.0e-18;
    localparam real rsub_eff = (rsub_val > 10.0e-3) ? rsub_val : 10.0e-3;
    localparam real lfeed_eff = (lfeed_val > 1.0e-18) ? lfeed_val : 1.0e-18;

    // TODO: use device primitives from LRM annex E instead?
    capacitor #(.c(cic0)) Cic1(PLUS, bn);
    capacitor #(.c(cic0)) Cic2(MINUS, bn);
    inductor #(.l(lskin_val)) Lskin(PLUS, n2);
    resistor #(.r(rskin_val)) Rskin(PLUS, n2);
    inductor #(.l(lmim_eff)) Lmim(n2, n3);
    resistor #(.r(rmim_val)) Rmim(n3, n4);
    cap_cmim #(.l(l), .w(w), .mm_ok(mm_ok)) cmim(n4, n5);
    capacitor #(.c(cox_val)) Cox(n5, n51);
    capacitor #(.c(csub_val)) Csub(n51, bn);
    resistor #(.r(rsub_eff)) Rsub(n51, bn);
    inductor #(.l(lfeed_eff)) Lfeed(n5, MINUS);
    resistor #(.r(1G)) Rdummy(n5, bn);
endmodule
