`include "disciplines.vams"

`define cap_carea (`cap_carea_norm)
`define cap_cpara (`cap_cpara_norm)
