`include "disciplines.vams"

`ifdef cap_typ
`define cap_carea 1.5E-15
`define cap_cpara 1.0
`include "capacitors_mod.va"
`endif

`ifdef cap_typ_stat
`define cap_carea_norm 1.5E-15
`define cap_cpara_norm 1.0
`include "capacitors_stat.va"
`include "capacitors_mod.va"
`endif

`ifdef cap_bcs
`define cap_carea 0.9 * 1.5E-15
`define cap_cpara 0.9
`include "capacitors_mod.va"
`endif

`ifdef cap_wcs
`define cap_carea 1.1 * 1.5E-15
`define cap_cpara 1.1
`include "capacitors_mod.va"
`endif
