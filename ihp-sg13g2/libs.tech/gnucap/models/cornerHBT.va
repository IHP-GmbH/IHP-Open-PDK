`include "disciplines.vams"

`ifdef hbt_typ
`define vbic_cje 1.0
`define vbic_cjc 1.0
`define vbic_cjcp 1.0
`define vbic_is 1.0
`define vbic_ibei 1.0
`define vbic_re 1.0
`define vbic_rcx 1.0
`define vbic_rbx 1.0
`define vbic_tf 1.0
`define sgp_mpa_cje 1.0
`define sgp_mpa_cjc 1.0
`define sgp_mpa_is 1.0
`define sgp_mpa_bf 1.0
`define sgp_mpa_re 1.0
`define sgp_mpa_rb 1.0
`define sgp_mpa_rc 1.0
`include "sg13g2_hbt_mod.va"
`endif

`ifdef hbt_typ_stat
`define vbic_cje_norm 1.0
`define vbic_cjc_norm 1.0
`define vbic_cjcp_norm 1.0
`define vbic_is_norm 1.0
`define vbic_ibei_norm 1.0
`define vbic_re_norm 1.0
`define vbic_rcx_norm 1.0
`define vbic_rbx_norm 1.0
`define vbic_tf 1.0
`define sgp_mpa_cje_norm 1.0
`define sgp_mpa_cjc_norm 1.0
`define sgp_mpa_is_norm 1.0
`define sgp_mpa_bf_norm 1.0
`define sgp_mpa_re_norm 1.0
`define sgp_mpa_rb_norm 1.0
`define sgp_mpa_rc_norm 1.0
`include "sg13g2_hbt_stat.va"
`include "sg13g2_hbt_mod.va"
`endif

`ifdef hbt_bcs
`define vbic_cje 0.83
`define vbic_cjc 0.87
`define vbic_cjcp 0.89
`define vbic_is 1.26
`define vbic_ibei 0.67
`define vbic_re 0.73
`define vbic_rcx 0.79
`define vbic_rbx 0.88
`define vbic_tf 0.89
`define sgp_mpa_cje 0.955
`define sgp_mpa_cjc 0.98
`define sgp_mpa_is 1.13
`define sgp_mpa_bf 1.24
`define sgp_mpa_re 0.952
`define sgp_mpa_rb 0.975
`define sgp_mpa_rc 0.95
`include "sg13g2_hbt_mod.va"
`endif

`ifdef hbt_wcs
`define vbic_cje 1.17
`define vbic_cjc 1.13
`define vbic_cjcp 1.11
`define vbic_is 0.74
`define vbic_ibei 1.33
`define vbic_re 1.27
`define vbic_rcx 1.21
`define vbic_rbx 1.12
`define vbic_tf 1.11
`define sgp_mpa_cje 1.045
`define sgp_mpa_cjc 1.02
`define sgp_mpa_is 0.87
`define sgp_mpa_bf 0.76
`define sgp_mpa_re 1.048
`define sgp_mpa_rb 1.025
`define sgp_mpa_rc 1.05
`include "sg13g2_hbt_mod.va"
`endif
