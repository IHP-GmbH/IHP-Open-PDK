//******************************************************************************
//                                                                             *
// Library:      SG13G2_dev                                                    *
// Technologies: SG13G2                                                        *
// Component:    Spice model file                                              *
//                                                                             *
// Simulator:    NGSPICE                                                       *
// Model:        PSP 103.6                                                     *
// Revision:     210511                                                        *
//                                                                             *
//******************************************************************************
//                                                                             *
// Copyright 2026 IHP PDK Authors                                              *
//                                                                             *
// Licensed under the Apache License, Version 2.0 (the "License");             *
// you may not use this file except in compliance with the License.            *
// You may obtain a copy of the License at                                     *
//                                                                             *
//     https://www.apache.org/licenses/LICENSE-2.0                             *
//                                                                             *
// Unless required by applicable law or agreed to in writing, software         *
// distributed under the License is distributed on an "AS IS" BASIS,           *
// WITHOUT WARRANTIES OR CONDITIONS OF ANY KIND, either express or implied.    *
// See the License for the specific language governing permissions and         *
// limitations under the License.                                              *
//                                                                             *
//******************************************************************************
//******************************************************************************
//                                                                             *
//                                                                             *
//                      M O S C A P   C O R N E R S                            *
//                                                                             *
//                                                                             *
//******************************************************************************
//
// NOTE: use only typical mean file (this file) for Monte Carlo simulations of process tolerance!
//
// MOS capacitors use the low-voltage MOS PSP103 model cards with dedicated
// two-terminal MOSCAP subcircuits.  Keep this corner entry point separate from
// cornerMOSlv.va so MOSCAP users do not include MOS transistor wrappers.
//
// Corner naming scheme: typical mean=tt, worst case=ss, best case=ff, combinations sf, fs, ...
// Monte-Carlo begin ---------------------------------------------
//
// NOTE: default of all   parameters should be 1.0
// NOTE: deviations from 1.0 are used to fit statistical results
//
//******************************************************************************

//******************************************************************************
// Verilog-A MOSCAP corner modules
// Ported from `ngspice/models/cornerMOSCAP.lib`
//
// Modifications:
// - removed mismatch corners; mismatch variants are implemented in paramsets
// - moved global process-variation parameters into statistical corner
// - changed norm suffix to nom for nominal
// - dropped num_sigmas parameter
//
// (c) Lukas Deutz 2026
//******************************************************************************

//*************** CORNER_LIB OF sg13g2 MOSCAP TT MODEL ****************

module moscap_tt();
    // nmos
    localparam real sg13g2_moscap_n_vfbo    = 1.0;
    localparam real sg13g2_moscap_n_ctl     = 1.2080;
    localparam real sg13g2_moscap_n_rsw1    = 0.7200;
    localparam real sg13g2_moscap_n_muew    = 0.8500;
    localparam real sg13g2_moscap_n_dphibo  = 0.9915;
    localparam real sg13g2_moscap_n_dphibl  = 0.9693;
    localparam real sg13g2_moscap_n_dphibw  = 0.9749;
    localparam real sg13g2_moscap_n_dphiblw = 0.9754;
    localparam real sg13g2_moscap_n_themuo  = 0.8757;
    localparam real sg13g2_moscap_n_thesatl = 0.7850;
    localparam real sg13g2_moscap_n_thesatw = 1.5000;
    localparam real sg13g2_moscap_n_thesatlw= 0.6127;
    localparam real sg13g2_moscap_n_toxo    = 1.0000;
    localparam real sg13g2_moscap_n_toxovo  = 1.0000;
    localparam real sg13g2_moscap_n_cjorbot = 1.0000;
    localparam real sg13g2_moscap_n_cjorsti = 1.0000;
    localparam real sg13g2_moscap_n_cjorgat = 1.0000;
    // pmos
    localparam real sg13g2_moscap_p_vfbo    = 1.0;
    localparam real sg13g2_moscap_p_ctl     = 1.9570;
    localparam real sg13g2_moscap_p_rsw1    = 0.7720;
    localparam real sg13g2_moscap_p_muew    = 1.0520;
    localparam real sg13g2_moscap_p_dphibo  = 0.9050;
    localparam real sg13g2_moscap_p_dphibl  = 0.8550;
    localparam real sg13g2_moscap_p_dphibw  = -1.5800;
    localparam real sg13g2_moscap_p_dphiblw = 1.0000;
    localparam real sg13g2_moscap_p_themuo  = 0.9580;
    localparam real sg13g2_moscap_p_thesatl = 0.5510;
    localparam real sg13g2_moscap_p_thesatw = 1.0800;
    localparam real sg13g2_moscap_p_thesatlw= 1.0000;
    localparam real sg13g2_moscap_p_toxo    = 1.0000;
    localparam real sg13g2_moscap_p_toxovo  = 1.0000;
    localparam real sg13g2_moscap_p_cjorbot = 1.0000;
    localparam real sg13g2_moscap_p_cjorsti = 1.0000;
    localparam real sg13g2_moscap_p_cjorgat = 1.0000;
endmodule

// Typical with statistical
module moscap_tt_stat();
    parameter integer seed = 1 from [0:1000000); // TODO: upper inf not working yet
    // nmos nominal
    localparam real sg13g2_moscap_n_vfbo_nom    = 1.0;
    localparam real sg13g2_moscap_n_ctl_nom     = 1.2080;
    localparam real sg13g2_moscap_n_rsw1_nom    = 0.7200;
    localparam real sg13g2_moscap_n_muew_nom    = 0.8500;
    localparam real sg13g2_moscap_n_dphibo_nom  = 0.9915;
    localparam real sg13g2_moscap_n_dphibl_nom  = 0.9693;
    localparam real sg13g2_moscap_n_dphibw_nom  = 0.9749;
    localparam real sg13g2_moscap_n_dphiblw_nom = 0.9754;
    localparam real sg13g2_moscap_n_themuo_nom  = 0.8757;
    localparam real sg13g2_moscap_n_thesatl_nom = 0.7850;
    localparam real sg13g2_moscap_n_thesatw_nom = 1.5000;
    localparam real sg13g2_moscap_n_thesatlw_nom= 0.6127;
    localparam real sg13g2_moscap_n_toxo_nom    = 1.0000;
    localparam real sg13g2_moscap_n_toxovo_nom  = 1.0000;
    localparam real sg13g2_moscap_n_cjorbot_nom = 1.0000;
    localparam real sg13g2_moscap_n_cjorsti_nom = 1.0000;
    localparam real sg13g2_moscap_n_cjorgat_nom = 1.0000;
    // nmos sig
    localparam real sg13g2_moscap_n_vfbo_sig    = 0.0050 * abs(sg13g2_moscap_n_vfbo_nom);
    localparam real sg13g2_moscap_n_ctl_sig     = 0.1562 * abs(sg13g2_moscap_n_ctl_nom);
    localparam real sg13g2_moscap_n_rsw1_sig    = 0.0407 * abs(sg13g2_moscap_n_rsw1_nom);
    localparam real sg13g2_moscap_n_muew_sig    = 0.0320 * abs(sg13g2_moscap_n_muew_nom);
    localparam real sg13g2_moscap_n_dphibo_sig  = 0.0656 * abs(sg13g2_moscap_n_dphibo_nom);
    localparam real sg13g2_moscap_n_dphibl_sig  = 0.1135 * abs(sg13g2_moscap_n_dphibl_nom);
    localparam real sg13g2_moscap_n_dphibw_sig  = 0.1197 * abs(sg13g2_moscap_n_dphibw_nom);
    localparam real sg13g2_moscap_n_dphiblw_sig = 0.0135 * abs(sg13g2_moscap_n_dphiblw_nom);
    localparam real sg13g2_moscap_n_themuo_sig  = 0.0026 * abs(sg13g2_moscap_n_themuo_nom);
    localparam real sg13g2_moscap_n_thesatl_sig = 0.0908 * abs(sg13g2_moscap_n_thesatl_nom);
    localparam real sg13g2_moscap_n_thesatw_sig = 0.0272 * abs(sg13g2_moscap_n_thesatw_nom);
    localparam real sg13g2_moscap_n_thesatlw_sig= 0.1503 * abs(sg13g2_moscap_n_thesatlw_nom);
    localparam real sg13g2_moscap_n_toxo_sig    = 0.0133 * abs(sg13g2_moscap_n_toxo_nom);
    localparam real sg13g2_moscap_n_toxovo_sig  = 0.0133 * abs(sg13g2_moscap_n_toxovo_nom);
    localparam real sg13g2_moscap_n_cjorbot_sig = 0.0267 * abs(sg13g2_moscap_n_cjorbot_nom);
    localparam real sg13g2_moscap_n_cjorsti_sig = 0.0267 * abs(sg13g2_moscap_n_cjorsti_nom);
    localparam real sg13g2_moscap_n_cjorgat_sig = 0.0267 * abs(sg13g2_moscap_n_cjorgat_nom);
    // nmos params with global process variation
    localparam real sg13g2_moscap_n_vfbo    = sg13g2_moscap_n_vfbo_nom     + $rdist_normal(seed + 1 , 0, sg13g2_moscap_n_vfbo_sig,     "global");
    localparam real sg13g2_moscap_n_ctl     = sg13g2_moscap_n_ctl_nom      + $rdist_normal(seed + 2 , 0, sg13g2_moscap_n_ctl_sig,      "global");
    localparam real sg13g2_moscap_n_rsw1    = sg13g2_moscap_n_rsw1_nom     + $rdist_normal(seed + 3 , 0, sg13g2_moscap_n_rsw1_sig,     "global");
    localparam real sg13g2_moscap_n_muew    = sg13g2_moscap_n_muew_nom     + $rdist_normal(seed + 4 , 0, sg13g2_moscap_n_muew_sig,     "global");
    localparam real sg13g2_moscap_n_dphibo  = sg13g2_moscap_n_dphibo_nom   + $rdist_normal(seed + 5 , 0, sg13g2_moscap_n_dphibo_sig,   "global");
    localparam real sg13g2_moscap_n_dphibl  = sg13g2_moscap_n_dphibl_nom   + $rdist_normal(seed + 6 , 0, sg13g2_moscap_n_dphibl_sig,   "global");
    localparam real sg13g2_moscap_n_dphibw  = sg13g2_moscap_n_dphibw_nom   + $rdist_normal(seed + 7 , 0, sg13g2_moscap_n_dphibw_sig,   "global");
    localparam real sg13g2_moscap_n_dphiblw = sg13g2_moscap_n_dphiblw_nom  + $rdist_normal(seed + 8 , 0, sg13g2_moscap_n_dphiblw_sig,  "global");
    localparam real sg13g2_moscap_n_themuo  = sg13g2_moscap_n_themuo_nom   + $rdist_normal(seed + 9 , 0, sg13g2_moscap_n_themuo_sig,   "global");
    localparam real sg13g2_moscap_n_thesatl = sg13g2_moscap_n_thesatl_nom  + $rdist_normal(seed + 10, 0, sg13g2_moscap_n_thesatl_sig,  "global");
    localparam real sg13g2_moscap_n_thesatw = sg13g2_moscap_n_thesatw_nom  + $rdist_normal(seed + 11, 0, sg13g2_moscap_n_thesatw_sig,  "global");
    localparam real sg13g2_moscap_n_thesatlw= sg13g2_moscap_n_thesatlw_nom + $rdist_normal(seed + 12, 0, sg13g2_moscap_n_thesatlw_sig, "global");
    localparam real sg13g2_moscap_n_toxo    = sg13g2_moscap_n_toxo_nom     + $rdist_normal(seed + 13, 0, sg13g2_moscap_n_toxo_sig,     "global");
    localparam real sg13g2_moscap_n_toxovo  = sg13g2_moscap_n_toxovo_nom   + $rdist_normal(seed + 14, 0, sg13g2_moscap_n_toxovo_sig,   "global");
    localparam real sg13g2_moscap_n_cjorbot = sg13g2_moscap_n_cjorbot_nom  + $rdist_normal(seed + 15, 0, sg13g2_moscap_n_cjorbot_sig,  "global");
    localparam real sg13g2_moscap_n_cjorsti = sg13g2_moscap_n_cjorsti_nom  + $rdist_normal(seed + 16, 0, sg13g2_moscap_n_cjorsti_sig,  "global");
    localparam real sg13g2_moscap_n_cjorgat = sg13g2_moscap_n_cjorgat_nom  + $rdist_normal(seed + 17, 0, sg13g2_moscap_n_cjorgat_sig,  "global");
    // pmos nominal parameter values
    localparam real sg13g2_moscap_p_vfbo_nom    = 1.0;
    localparam real sg13g2_moscap_p_ctl_nom     = 1.9570;
    localparam real sg13g2_moscap_p_rsw1_nom    = 0.7720;
    localparam real sg13g2_moscap_p_muew_nom    = 1.0520;
    localparam real sg13g2_moscap_p_dphibo_nom  = 0.9050;
    localparam real sg13g2_moscap_p_dphibl_nom  = 0.8550;
    localparam real sg13g2_moscap_p_dphibw_nom  = -1.5800;
    localparam real sg13g2_moscap_p_dphiblw_nom = 1.0000;
    localparam real sg13g2_moscap_p_themuo_nom  = 0.9580;
    localparam real sg13g2_moscap_p_thesatl_nom = 0.5510;
    localparam real sg13g2_moscap_p_thesatw_nom = 1.0800;
    localparam real sg13g2_moscap_p_thesatlw_nom= 1.0000;
    localparam real sg13g2_moscap_p_toxo_nom    = 1.0000;
    localparam real sg13g2_moscap_p_toxovo_nom  = 1.0000;
    localparam real sg13g2_moscap_p_cjorbot_nom = 1.0000;
    localparam real sg13g2_moscap_p_cjorsti_nom = 1.0000;
    localparam real sg13g2_moscap_p_cjorgat_nom = 1.0000;
    // pmos sig
    localparam real sg13g2_moscap_p_vfbo_sig    = 0.0050 * abs(sg13g2_moscap_p_vfbo_nom);
    localparam real sg13g2_moscap_p_ctl_sig     = 0.1880 * abs(sg13g2_moscap_p_ctl_nom);
    localparam real sg13g2_moscap_p_rsw1_sig    = 0.0727 * abs(sg13g2_moscap_p_rsw1_nom);
    localparam real sg13g2_moscap_p_muew_sig    = 0.0235 * abs(sg13g2_moscap_p_muew_nom);
    localparam real sg13g2_moscap_p_dphibo_sig  = 0.1078 * abs(sg13g2_moscap_p_dphibo_nom);
    localparam real sg13g2_moscap_p_dphibl_sig  = 0.1412 * abs(sg13g2_moscap_p_dphibl_nom);
    localparam real sg13g2_moscap_p_dphibw_sig  = 1.4858 * abs(sg13g2_moscap_p_dphibw_nom);
    localparam real sg13g2_moscap_p_dphiblw_sig = 1.0e-9 * abs(sg13g2_moscap_p_dphiblw_nom);
    localparam real sg13g2_moscap_p_themuo_sig  = 0.0247 * abs(sg13g2_moscap_p_themuo_nom);
    localparam real sg13g2_moscap_p_thesatl_sig = 0.1718 * abs(sg13g2_moscap_p_thesatl_nom);
    localparam real sg13g2_moscap_p_thesatw_sig = 0.0427 * abs(sg13g2_moscap_p_thesatw_nom);
    localparam real sg13g2_moscap_p_thesatlw_sig= 0.1667 * abs(sg13g2_moscap_p_thesatlw_nom);
    localparam real sg13g2_moscap_p_toxo_sig    = 0.0133 * abs(sg13g2_moscap_p_toxo_nom);
    localparam real sg13g2_moscap_p_toxovo_sig  = 0.0133 * abs(sg13g2_moscap_p_toxovo_nom);
    localparam real sg13g2_moscap_p_cjorbot_sig = 0.0267 * abs(sg13g2_moscap_p_cjorbot_nom);
    localparam real sg13g2_moscap_p_cjorsti_sig = 0.0267 * abs(sg13g2_moscap_p_cjorsti_nom);
    localparam real sg13g2_moscap_p_cjorgat_sig = 0.0267 * abs(sg13g2_moscap_p_cjorgat_nom);
    // pmos params with global process variation
    localparam real sg13g2_moscap_p_vfbo    = sg13g2_moscap_p_vfbo_nom     + $rdist_normal(seed + 18, 0, sg13g2_moscap_p_vfbo_sig,     "global");
    localparam real sg13g2_moscap_p_ctl     = sg13g2_moscap_p_ctl_nom      + $rdist_normal(seed + 19, 0, sg13g2_moscap_p_ctl_sig,      "global");
    localparam real sg13g2_moscap_p_rsw1    = sg13g2_moscap_p_rsw1_nom     + $rdist_normal(seed + 20, 0, sg13g2_moscap_p_rsw1_sig,     "global");
    localparam real sg13g2_moscap_p_muew    = sg13g2_moscap_p_muew_nom     + $rdist_normal(seed + 21, 0, sg13g2_moscap_p_muew_sig,     "global");
    localparam real sg13g2_moscap_p_dphibo  = sg13g2_moscap_p_dphibo_nom   + $rdist_normal(seed + 22, 0, sg13g2_moscap_p_dphibo_sig,   "global");
    localparam real sg13g2_moscap_p_dphibl  = sg13g2_moscap_p_dphibl_nom   + $rdist_normal(seed + 23, 0, sg13g2_moscap_p_dphibl_sig,   "global");
    localparam real sg13g2_moscap_p_dphibw  = sg13g2_moscap_p_dphibw_nom   + $rdist_normal(seed + 24, 0, sg13g2_moscap_p_dphibw_sig,   "global");
    localparam real sg13g2_moscap_p_dphiblw = sg13g2_moscap_p_dphiblw_nom  + $rdist_normal(seed + 25, 0, sg13g2_moscap_p_dphiblw_sig,  "global");
    localparam real sg13g2_moscap_p_themuo  = sg13g2_moscap_p_themuo_nom   + $rdist_normal(seed + 26, 0, sg13g2_moscap_p_themuo_sig,   "global");
    localparam real sg13g2_moscap_p_thesatl = sg13g2_moscap_p_thesatl_nom  + $rdist_normal(seed + 27, 0, sg13g2_moscap_p_thesatl_sig,  "global");
    localparam real sg13g2_moscap_p_thesatw = sg13g2_moscap_p_thesatw_nom  + $rdist_normal(seed + 28, 0, sg13g2_moscap_p_thesatw_sig,  "global");
    localparam real sg13g2_moscap_p_thesatlw= sg13g2_moscap_p_thesatlw_nom + $rdist_normal(seed + 29, 0, sg13g2_moscap_p_thesatlw_sig, "global");
    localparam real sg13g2_moscap_p_toxo    = sg13g2_moscap_p_toxo_nom     + $rdist_normal(seed + 30, 0, sg13g2_moscap_p_toxo_sig,     "global");
    localparam real sg13g2_moscap_p_toxovo  = sg13g2_moscap_p_toxovo_nom   + $rdist_normal(seed + 31, 0, sg13g2_moscap_p_toxovo_sig,   "global");
    localparam real sg13g2_moscap_p_cjorbot = sg13g2_moscap_p_cjorbot_nom  + $rdist_normal(seed + 32, 0, sg13g2_moscap_p_cjorbot_sig,  "global");
    localparam real sg13g2_moscap_p_cjorsti = sg13g2_moscap_p_cjorsti_nom  + $rdist_normal(seed + 33, 0, sg13g2_moscap_p_cjorsti_sig,  "global");
    localparam real sg13g2_moscap_p_cjorgat = sg13g2_moscap_p_cjorgat_nom  + $rdist_normal(seed + 34, 0, sg13g2_moscap_p_cjorgat_sig,  "global");
endmodule
