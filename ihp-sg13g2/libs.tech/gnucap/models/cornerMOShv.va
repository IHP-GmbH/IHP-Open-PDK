`include "disciplines.vams"

`ifdef mos_tt
`define sg13g2_hv_nmos_vfbo_mm 1.0
`define sg13g2_hv_nmos_rsgo 1.0000
`define sg13g2_hv_nmos_rsw1 0.7886
`define sg13g2_hv_nmos_mueo 1.0780
`define sg13g2_hv_nmos_dphibo 1.4388
`define sg13g2_hv_nmos_dphibl 1.5299
`define sg13g2_hv_nmos_dphibw 1.0000
`define sg13g2_hv_nmos_dphiblw 0.8712
`define sg13g2_hv_nmos_ctl 1.0000
`define sg13g2_hv_nmos_thesato 1.0000
`define sg13g2_hv_nmos_thesatl 1.0350
`define sg13g2_hv_nmos_thesatw 1.0000
`define sg13g2_hv_nmos_thesatlw 1.6050
`define sg13g2_hv_nmos_toxo 1.0000
`define sg13g2_hv_nmos_toxovo 1.0000
`define sg13g2_hv_nmos_cjorbot 1.0000
`define sg13g2_hv_nmos_cjorsti 1.0000
`define sg13g2_hv_nmos_cjorgat 1.0000
`define sg13g2_hv_pmos_vfbo_mm 1.0
`define sg13g2_hv_pmos_rsgo 1.1110
`define sg13g2_hv_pmos_rsw1 1.0000
`define sg13g2_hv_pmos_mueo 0.9605
`define sg13g2_hv_pmos_dphibo 1.0010
`define sg13g2_hv_pmos_dphibl 0.9504
`define sg13g2_hv_pmos_dphibw 1.4080
`define sg13g2_hv_pmos_dphiblw -0.1693
`define sg13g2_hv_pmos_bgidlo 0.8409
`define sg13g2_hv_pmos_thesato 1.0000
`define sg13g2_hv_pmos_thesatl 0.4814
`define sg13g2_hv_pmos_thesatw 5.7745
`define sg13g2_hv_pmos_thesatlw 1.0000
`define sg13g2_hv_pmos_csl 1.0000
`define sg13g2_hv_pmos_toxo 1.0000
`define sg13g2_hv_pmos_toxovo 1.0000
`define sg13g2_hv_pmos_cjorbot 1.0000
`define sg13g2_hv_pmos_cjorsti 1.0000
`define sg13g2_hv_pmos_cjorgat 1.0000
`define sg13g2_hv_svaricap_lap 0.8
`define sg13g2_hv_svaricap_toxo 1
`include "sg13g2_moshv_mod.va"
`endif

`ifdef mos_tt_stat
`define sg13g2_hv_nmos_vfbo_mm_norm 1.0
`define sg13g2_hv_nmos_rsgo_norm 1.0000
`define sg13g2_hv_nmos_rsw1_norm 0.7886
`define sg13g2_hv_nmos_mueo_norm 1.0780
`define sg13g2_hv_nmos_dphibo_norm 1.4388
`define sg13g2_hv_nmos_dphibl_norm 1.5299
`define sg13g2_hv_nmos_dphibw_norm 1.0000
`define sg13g2_hv_nmos_dphiblw_norm 0.8712
`define sg13g2_hv_nmos_ctl_norm 1.0000
`define sg13g2_hv_nmos_thesato_norm 1.0000
`define sg13g2_hv_nmos_thesatl_norm 1.0350
`define sg13g2_hv_nmos_thesatw_norm 1.0000
`define sg13g2_hv_nmos_thesatlw_norm 1.6050
`define sg13g2_hv_nmos_toxo_norm 1.0000
`define sg13g2_hv_nmos_toxovo_norm 1.0000
`define sg13g2_hv_nmos_cjorbot_norm 1.0000
`define sg13g2_hv_nmos_cjorsti_norm 1.0000
`define sg13g2_hv_nmos_cjorgat_norm 1.0000
`define sg13g2_hv_pmos_vfbo_mm_norm 1.0
`define sg13g2_hv_pmos_rsgo_norm 1.1110
`define sg13g2_hv_pmos_rsw1_norm 1.0000
`define sg13g2_hv_pmos_mueo_norm 0.9605
`define sg13g2_hv_pmos_dphibo_norm 1.0010
`define sg13g2_hv_pmos_dphibl_norm 0.9504
`define sg13g2_hv_pmos_dphibw_norm 1.4080
`define sg13g2_hv_pmos_dphiblw_norm -0.1693
`define sg13g2_hv_pmos_bgidlo_norm 0.8409
`define sg13g2_hv_pmos_thesato_norm 1.0000
`define sg13g2_hv_pmos_thesatl_norm 0.4814
`define sg13g2_hv_pmos_thesatw_norm 5.7745
`define sg13g2_hv_pmos_thesatlw_norm 1.0000
`define sg13g2_hv_pmos_csl_norm 1.0000
`define sg13g2_hv_pmos_toxo_norm 1.0000
`define sg13g2_hv_pmos_toxovo_norm 1.0000
`define sg13g2_hv_pmos_cjorbot_norm 1.0000
`define sg13g2_hv_pmos_cjorsti_norm 1.0000
`define sg13g2_hv_pmos_cjorgat_norm 1.0000
`define sg13g2_hv_svaricap_lap 0.8
`define sg13g2_hv_svaricap_toxo 1
`include "sg13g2_moshv_stat.va"
`include "sg13g2_moshv_mod.va"
`endif

`ifdef mos_ss
`define sg13g2_hv_nmos_vfbo_mm 1.0
`define sg13g2_hv_nmos_rsgo 1.0000
`define sg13g2_hv_nmos_rsw1 0.7880
`define sg13g2_hv_nmos_mueo 1.1670
`define sg13g2_hv_nmos_dphibo 1.0117
`define sg13g2_hv_nmos_dphibl 0.9004
`define sg13g2_hv_nmos_dphibw 1.0000
`define sg13g2_hv_nmos_dphiblw 0.8247
`define sg13g2_hv_nmos_ctl 1.0000
`define sg13g2_hv_nmos_thesato 1.0000
`define sg13g2_hv_nmos_thesatl 1.1610
`define sg13g2_hv_nmos_thesatw 1.0000
`define sg13g2_hv_nmos_thesatlw 1.4830
`define sg13g2_hv_nmos_toxo 1.0400
`define sg13g2_hv_nmos_toxovo 1.0400
`define sg13g2_hv_nmos_cjorbot 1.0800
`define sg13g2_hv_nmos_cjorsti 1.0800
`define sg13g2_hv_nmos_cjorgat 1.0800
`define sg13g2_hv_pmos_vfbo_mm 1.0
`define sg13g2_hv_pmos_rsgo -0.0510
`define sg13g2_hv_pmos_rsw1 1.0000
`define sg13g2_hv_pmos_mueo 0.9619
`define sg13g2_hv_pmos_dphibo 0.8319
`define sg13g2_hv_pmos_dphibl 1.1490
`define sg13g2_hv_pmos_dphibw 1.4480
`define sg13g2_hv_pmos_dphiblw 2.7230
`define sg13g2_hv_pmos_bgidlo 1.4000
`define sg13g2_hv_pmos_thesato 1.0000
`define sg13g2_hv_pmos_thesatl 0.6000
`define sg13g2_hv_pmos_thesatw 3.7378
`define sg13g2_hv_pmos_thesatlw 1.0000
`define sg13g2_hv_pmos_csl 1.0000
`define sg13g2_hv_pmos_toxo 1.0400
`define sg13g2_hv_pmos_toxovo 1.0400
`define sg13g2_hv_pmos_cjorbot 1.0800
`define sg13g2_hv_pmos_cjorsti 1.0800
`define sg13g2_hv_pmos_cjorgat 1.0800
`define sg13g2_hv_svaricap_lap 0.6
`define sg13g2_hv_svaricap_toxo 1.04
`include "sg13g2_moshv_mod.va"
`endif

`ifdef mos_ff
`define sg13g2_hv_nmos_vfbo_mm 1.0
`define sg13g2_hv_nmos_rsgo 1.0000
`define sg13g2_hv_nmos_rsw1 0.7880
`define sg13g2_hv_nmos_mueo 0.9662
`define sg13g2_hv_nmos_dphibo 1.9136
`define sg13g2_hv_nmos_dphibl 2.1315
`define sg13g2_hv_nmos_dphibw 1.0000
`define sg13g2_hv_nmos_dphiblw 0.9151
`define sg13g2_hv_nmos_ctl 1.0000
`define sg13g2_hv_nmos_thesato 1.0000
`define sg13g2_hv_nmos_thesatl 0.9463
`define sg13g2_hv_nmos_thesatw 1.0000
`define sg13g2_hv_nmos_thesatlw 1.6950
`define sg13g2_hv_nmos_toxo 0.9600
`define sg13g2_hv_nmos_toxovo 0.9600
`define sg13g2_hv_nmos_cjorbot 0.9200
`define sg13g2_hv_nmos_cjorsti 0.9200
`define sg13g2_hv_nmos_cjorgat 0.9200
`define sg13g2_hv_pmos_vfbo_mm 1.0
`define sg13g2_hv_pmos_rsgo 2.5010
`define sg13g2_hv_pmos_rsw1 1.0000
`define sg13g2_hv_pmos_mueo 0.9687
`define sg13g2_hv_pmos_dphibo 1.1750
`define sg13g2_hv_pmos_dphibl 0.7456
`define sg13g2_hv_pmos_dphibw 1.3380
`define sg13g2_hv_pmos_dphiblw -3.3600
`define sg13g2_hv_pmos_bgidlo 0.4770
`define sg13g2_hv_pmos_thesato 1.0000
`define sg13g2_hv_pmos_thesatl 0.5000
`define sg13g2_hv_pmos_thesatw 6.3581
`define sg13g2_hv_pmos_thesatlw 1.0000
`define sg13g2_hv_pmos_csl 1.0000
`define sg13g2_hv_pmos_toxo 0.9600
`define sg13g2_hv_pmos_toxovo 0.9600
`define sg13g2_hv_pmos_cjorbot 0.9200
`define sg13g2_hv_pmos_cjorsti 0.9200
`define sg13g2_hv_pmos_cjorgat 0.9200
`define sg13g2_hv_svaricap_lap 1
`define sg13g2_hv_svaricap_toxo 0.96
`include "sg13g2_moshv_mod.va"
`endif

`ifdef mos_sf
`define sg13g2_hv_nmos_vfbo_mm 1.0
`define sg13g2_hv_nmos_rsgo 1.0000
`define sg13g2_hv_nmos_rsw1 0.7883
`define sg13g2_hv_nmos_mueo 1.1225
`define sg13g2_hv_nmos_dphibo 1.2252
`define sg13g2_hv_nmos_dphibl 1.2151
`define sg13g2_hv_nmos_dphibw 1.0000
`define sg13g2_hv_nmos_dphiblw 0.8479
`define sg13g2_hv_nmos_ctl 1.0000
`define sg13g2_hv_nmos_thesato 1.0000
`define sg13g2_hv_nmos_thesatl 1.0980
`define sg13g2_hv_nmos_thesatw 1.0000
`define sg13g2_hv_nmos_thesatlw 1.5440
`define sg13g2_hv_nmos_toxo 1.0200
`define sg13g2_hv_nmos_toxovo 1.0200
`define sg13g2_hv_nmos_cjorbot 1.0400
`define sg13g2_hv_nmos_cjorsti 1.0400
`define sg13g2_hv_nmos_cjorgat 1.0400
`define sg13g2_hv_pmos_vfbo_mm 1.0
`define sg13g2_hv_pmos_rsgo 1.8060
`define sg13g2_hv_pmos_rsw1 1.0000
`define sg13g2_hv_pmos_mueo 0.9646
`define sg13g2_hv_pmos_dphibo 1.0880
`define sg13g2_hv_pmos_dphibl 0.8480
`define sg13g2_hv_pmos_dphibw 1.3730
`define sg13g2_hv_pmos_dphiblw -1.7647
`define sg13g2_hv_pmos_bgidlo 0.6589
`define sg13g2_hv_pmos_thesato 1.0000
`define sg13g2_hv_pmos_thesatl 0.4907
`define sg13g2_hv_pmos_thesatw 6.0663
`define sg13g2_hv_pmos_thesatlw 1.0000
`define sg13g2_hv_pmos_csl 1.0000
`define sg13g2_hv_pmos_toxo 0.9800
`define sg13g2_hv_pmos_toxovo 0.9800
`define sg13g2_hv_pmos_cjorbot 0.9600
`define sg13g2_hv_pmos_cjorsti 0.9600
`define sg13g2_hv_pmos_cjorgat 0.9600
`define sg13g2_hv_svaricap_lap 0.9
`define sg13g2_hv_svaricap_toxo 0.98
`include "sg13g2_moshv_mod.va"
`endif

`ifdef mos_fs
`define sg13g2_hv_nmos_vfbo_mm 1.0
`define sg13g2_hv_nmos_rsgo 1.0000
`define sg13g2_hv_nmos_rsw1 0.7883
`define sg13g2_hv_nmos_mueo 1.0221
`define sg13g2_hv_nmos_dphibo 1.6762
`define sg13g2_hv_nmos_dphibl 1.8307
`define sg13g2_hv_nmos_dphibw 1.0000
`define sg13g2_hv_nmos_dphiblw 0.8932
`define sg13g2_hv_nmos_ctl 1.0000
`define sg13g2_hv_nmos_thesato 1.0000
`define sg13g2_hv_nmos_thesatl 0.9907
`define sg13g2_hv_nmos_thesatw 1.0000
`define sg13g2_hv_nmos_thesatlw 1.6500
`define sg13g2_hv_nmos_toxo 0.9800
`define sg13g2_hv_nmos_toxovo 0.9800
`define sg13g2_hv_nmos_cjorbot 0.9600
`define sg13g2_hv_nmos_cjorsti 0.9600
`define sg13g2_hv_nmos_cjorgat 0.9600
`define sg13g2_hv_pmos_vfbo_mm 1.0
`define sg13g2_hv_pmos_rsgo 0.5300
`define sg13g2_hv_pmos_rsw1 1.0000
`define sg13g2_hv_pmos_mueo 0.9612
`define sg13g2_hv_pmos_dphibo 0.9164
`define sg13g2_hv_pmos_dphibl 1.0497
`define sg13g2_hv_pmos_dphibw 1.4280
`define sg13g2_hv_pmos_dphiblw 1.2769
`define sg13g2_hv_pmos_bgidlo 1.1204
`define sg13g2_hv_pmos_thesato 1.0000
`define sg13g2_hv_pmos_thesatl 0.5407
`define sg13g2_hv_pmos_thesatw 4.7562
`define sg13g2_hv_pmos_thesatlw 1.0000
`define sg13g2_hv_pmos_csl 1.0000
`define sg13g2_hv_pmos_toxo 1.0200
`define sg13g2_hv_pmos_toxovo 1.0200
`define sg13g2_hv_pmos_cjorbot 1.0400
`define sg13g2_hv_pmos_cjorsti 1.0400
`define sg13g2_hv_pmos_cjorgat 1.0400
`define sg13g2_hv_svaricap_lap 0.7
`define sg13g2_hv_svaricap_toxo 1.02
`include "sg13g2_moshv_mod.va"
`endif
