`include "disciplines.vams"

`ifdef mos_tt
`define sg13g2_lv_nmos_vfbo_mm 1.0
`define sg13g2_lv_nmos_ctl 1.2080
`define sg13g2_lv_nmos_rsw1 0.7200
`define sg13g2_lv_nmos_muew 0.8500
`define sg13g2_lv_nmos_dphibo 0.9915
`define sg13g2_lv_nmos_dphibl 0.9693
`define sg13g2_lv_nmos_dphibw 0.9749
`define sg13g2_lv_nmos_dphiblw 0.9754
`define sg13g2_lv_nmos_themuo 0.8757
`define sg13g2_lv_nmos_thesatl 0.7850
`define sg13g2_lv_nmos_thesatw 1.5000
`define sg13g2_lv_nmos_thesatlw 0.6127
`define sg13g2_lv_nmos_toxo 1.0000
`define sg13g2_lv_nmos_toxovo 1.0000
`define sg13g2_lv_nmos_cjorbot 1.0000
`define sg13g2_lv_nmos_cjorsti 1.0000
`define sg13g2_lv_nmos_cjorgat 1.0000
`define sg13g2_lv_pmos_vfbo_mm 1.0
`define sg13g2_lv_pmos_ctl 1.9570
`define sg13g2_lv_pmos_rsw1 0.7720
`define sg13g2_lv_pmos_muew 1.0520
`define sg13g2_lv_pmos_dphibo 0.9050
`define sg13g2_lv_pmos_dphibl 0.8550
`define sg13g2_lv_pmos_dphibw -1.5800
`define sg13g2_lv_pmos_dphiblw 1.0000
`define sg13g2_lv_pmos_themuo 0.9580
`define sg13g2_lv_pmos_thesatl 0.5510
`define sg13g2_lv_pmos_thesatw 1.0800
`define sg13g2_lv_pmos_thesatlw 1.0000
`define sg13g2_lv_pmos_toxo 1.0000
`define sg13g2_lv_pmos_toxovo 1.0000
`define sg13g2_lv_pmos_cjorbot 1.0000
`define sg13g2_lv_pmos_cjorsti 1.0000
`define sg13g2_lv_pmos_cjorgat 1.0000
`define sg13g2_lv_svaricap_lap 1.082
`define sg13g2_lv_svaricap_toxo 1
`include "sg13g2_moslv_mod.va"
`endif

`ifdef mos_tt_stat
`define sg13g2_lv_nmos_vfbo_norm 1.0
`define sg13g2_lv_nmos_ctl_norm 1.2080
`define sg13g2_lv_nmos_rsw1_norm 0.7200
`define sg13g2_lv_nmos_muew_norm 0.8500
`define sg13g2_lv_nmos_dphibo_norm 0.9915
`define sg13g2_lv_nmos_dphibl_norm 0.9693
`define sg13g2_lv_nmos_dphibw_norm 0.9749
`define sg13g2_lv_nmos_dphiblw_norm 0.9754
`define sg13g2_lv_nmos_themuo_norm 0.8757
`define sg13g2_lv_nmos_thesatl_norm 0.7850
`define sg13g2_lv_nmos_thesatw_norm 1.5000
`define sg13g2_lv_nmos_thesatlw_norm 0.6127
`define sg13g2_lv_nmos_toxo_norm 1.0000
`define sg13g2_lv_nmos_toxovo_norm 1.0000
`define sg13g2_lv_nmos_cjorbot_norm 1.0000
`define sg13g2_lv_nmos_cjorsti_norm 1.0000
`define sg13g2_lv_nmos_cjorgat_norm 1.0000
`define sg13g2_lv_pmos_vfbo_norm 1.0
`define sg13g2_lv_pmos_ctl_norm 1.2080
`define sg13g2_lv_pmos_rsw1_norm 0.7200
`define sg13g2_lv_pmos_muew_norm 0.8500
`define sg13g2_lv_pmos_dphibo_norm 0.9915
`define sg13g2_lv_pmos_dphibl_norm 0.9693
`define sg13g2_lv_pmos_dphibw_norm 0.9749
`define sg13g2_lv_pmos_dphiblw_norm 0.9754
`define sg13g2_lv_pmos_themuo_norm 0.8757
`define sg13g2_lv_pmos_thesatl_norm 0.7850
`define sg13g2_lv_pmos_thesatw_norm 1.5000
`define sg13g2_lv_pmos_thesatlw_norm 0.6127
`define sg13g2_lv_pmos_toxo_norm 1.0000
`define sg13g2_lv_pmos_toxovo_norm 1.0000
`define sg13g2_lv_pmos_cjorbot_norm 1.0000
`define sg13g2_lv_pmos_cjorsti_norm 1.0000
`define sg13g2_lv_pmos_cjorgat_norm 1.0000
`define sg13g2_lv_svaricap_lap 1.082
`define sg13g2_lv_svaricap_toxo 1
`include "sg13g2_moslv_stat.va"
`include "sg13g2_moslv_mod.va"
`endif

`ifdef mos_ss
`define sg13g2_lv_nmos_vfbo_mm 1.0
`define sg13g2_lv_nmos_ctl 0.4939
`define sg13g2_lv_nmos_rsw1 0.6560
`define sg13g2_lv_nmos_muew 0.9700
`define sg13g2_lv_nmos_dphibo 1.2070
`define sg13g2_lv_nmos_dphibl 1.3360
`define sg13g2_lv_nmos_dphibw 1.3290
`define sg13g2_lv_nmos_dphiblw 1.0110
`define sg13g2_lv_nmos_themuo 0.8866
`define sg13g2_lv_nmos_thesatl 1.0960
`define sg13g2_lv_nmos_thesatw 1.5930
`define sg13g2_lv_nmos_thesatlw 0.9875
`define sg13g2_lv_nmos_toxo 1.0400
`define sg13g2_lv_nmos_toxovo 1.0400
`define sg13g2_lv_nmos_cjorbot 1.0800
`define sg13g2_lv_nmos_cjorsti 1.0800
`define sg13g2_lv_nmos_cjorgat 1.0800
`define sg13g2_lv_pmos_vfbo_mm 1.0
`define sg13g2_lv_pmos_ctl 1.3520
`define sg13g2_lv_pmos_rsw1 0.9365
`define sg13g2_lv_pmos_muew 1.1030
`define sg13g2_lv_pmos_dphibo 0.5883
`define sg13g2_lv_pmos_dphibl 1.3540
`define sg13g2_lv_pmos_dphibw -4.9920
`define sg13g2_lv_pmos_dphiblw 1.0000
`define sg13g2_lv_pmos_themuo 0.8720
`define sg13g2_lv_pmos_thesatl 1.2190
`define sg13g2_lv_pmos_thesatw 0.9875
`define sg13g2_lv_pmos_thesatlw 1.0000
`define sg13g2_lv_pmos_toxo 1.0400
`define sg13g2_lv_pmos_toxovo 1.0400
`define sg13g2_lv_pmos_cjorbot 1.0800
`define sg13g2_lv_pmos_cjorsti 1.0800
`define sg13g2_lv_pmos_cjorgat 1.0800
`define sg13g2_lv_svaricap_lap 1
`define sg13g2_lv_svaricap_toxo 1.04
`include "sg13g2_moslv_mod.va"
`endif

`ifdef mos_ff
`define sg13g2_lv_nmos_vfbo_mm 1.0
`define sg13g2_lv_nmos_ctl 1.4310
`define sg13g2_lv_nmos_rsw1 0.9000
`define sg13g2_lv_nmos_muew 0.7780
`define sg13g2_lv_nmos_dphibo 0.8137
`define sg13g2_lv_nmos_dphibl 0.6550
`define sg13g2_lv_nmos_dphibw 0.6105
`define sg13g2_lv_nmos_dphiblw 0.9300
`define sg13g2_lv_nmos_themuo 0.8708
`define sg13g2_lv_nmos_thesatl 0.5510
`define sg13g2_lv_nmos_thesatw 1.4300
`define sg13g2_lv_nmos_thesatlw 0.0860
`define sg13g2_lv_nmos_toxo 0.9600
`define sg13g2_lv_nmos_toxovo 0.9600
`define sg13g2_lv_nmos_cjorbot 0.9200
`define sg13g2_lv_nmos_cjorsti 0.9200
`define sg13g2_lv_nmos_cjorgat 0.9200
`define sg13g2_lv_pmos_vfbo_mm 1.0
`define sg13g2_lv_pmos_ctl 2.4800
`define sg13g2_lv_pmos_rsw1 0.5000
`define sg13g2_lv_pmos_muew 0.9620
`define sg13g2_lv_pmos_dphibo 1.2350
`define sg13g2_lv_pmos_dphibl 0.5066
`define sg13g2_lv_pmos_dphibw 3.9230
`define sg13g2_lv_pmos_dphiblw 1.0000
`define sg13g2_lv_pmos_themuo 1.0200
`define sg13g2_lv_pmos_thesatl 0.1880
`define sg13g2_lv_pmos_thesatw 1.2440
`define sg13g2_lv_pmos_thesatlw 2.0000
`define sg13g2_lv_pmos_toxo 0.9600
`define sg13g2_lv_pmos_toxovo 0.9600
`define sg13g2_lv_pmos_cjorbot 0.9200
`define sg13g2_lv_pmos_cjorsti 0.9200
`define sg13g2_lv_pmos_cjorgat 0.9200
`define sg13g2_lv_svaricap_lap 1.24
`define sg13g2_lv_svaricap_toxo 0.96
`include "sg13g2_moslv_mod.va"
`endif

`ifdef mos_sf
`define sg13g2_lv_nmos_vfbo_mm 1.0
`define sg13g2_lv_nmos_ctl 0.8509
`define sg13g2_lv_nmos_rsw1 0.6880
`define sg13g2_lv_nmos_muew 0.9100
`define sg13g2_lv_nmos_dphibo 1.0993
`define sg13g2_lv_nmos_dphibl 1.1526
`define sg13g2_lv_nmos_dphibw 1.1520
`define sg13g2_lv_nmos_dphiblw 0.9932
`define sg13g2_lv_nmos_themuo 0.8812
`define sg13g2_lv_nmos_thesatl 0.9405
`define sg13g2_lv_nmos_thesatw 1.5465
`define sg13g2_lv_nmos_thesatlw 0.8001
`define sg13g2_lv_nmos_toxo 1.0200
`define sg13g2_lv_nmos_toxovo 1.0200
`define sg13g2_lv_nmos_cjorbot 1.0400
`define sg13g2_lv_nmos_cjorsti 1.0400
`define sg13g2_lv_nmos_cjorgat 1.0400
`define sg13g2_lv_pmos_vfbo_mm 1.0
`define sg13g2_lv_pmos_ctl 2.2185
`define sg13g2_lv_pmos_rsw1 0.6360
`define sg13g2_lv_pmos_muew 1.0070
`define sg13g2_lv_pmos_dphibo 1.0700
`define sg13g2_lv_pmos_dphibl 0.6808
`define sg13g2_lv_pmos_dphibw 1.1715
`define sg13g2_lv_pmos_dphiblw 1.0000
`define sg13g2_lv_pmos_themuo 0.9890
`define sg13g2_lv_pmos_thesatl 0.3695
`define sg13g2_lv_pmos_thesatw 1.1620
`define sg13g2_lv_pmos_thesatlw 1.5000
`define sg13g2_lv_pmos_toxo 0.9800
`define sg13g2_lv_pmos_toxovo 0.9800
`define sg13g2_lv_pmos_cjorbot 0.9600
`define sg13g2_lv_pmos_cjorsti 0.9600
`define sg13g2_lv_pmos_cjorgat 0.9600
`define sg13g2_lv_svaricap_lap 1.161
`define sg13g2_lv_svaricap_toxo 0.98
`include "sg13g2_moslv_mod.va"
`endif

`ifdef mos_fs
`define sg13g2_lv_nmos_vfbo_mm 1.0
`define sg13g2_lv_nmos_ctl 1.3195
`define sg13g2_lv_nmos_rsw1 0.8100
`define sg13g2_lv_nmos_muew 0.8140
`define sg13g2_lv_nmos_dphibo 0.9026
`define sg13g2_lv_nmos_dphibl 0.8122
`define sg13g2_lv_nmos_dphibw 0.7927
`define sg13g2_lv_nmos_dphiblw 0.9527
`define sg13g2_lv_nmos_themuo 0.8733
`define sg13g2_lv_nmos_thesatl 0.6680
`define sg13g2_lv_nmos_thesatw 1.4650
`define sg13g2_lv_nmos_thesatlw 0.3493
`define sg13g2_lv_nmos_toxo 0.9800
`define sg13g2_lv_nmos_toxovo 0.9800
`define sg13g2_lv_nmos_cjorbot 0.9600
`define sg13g2_lv_nmos_cjorsti 0.9600
`define sg13g2_lv_nmos_cjorgat 0.9600
`define sg13g2_lv_pmos_vfbo_mm 1.0
`define sg13g2_lv_pmos_ctl 1.6545
`define sg13g2_lv_pmos_rsw1 0.8542
`define sg13g2_lv_pmos_muew 1.0775
`define sg13g2_lv_pmos_dphibo 0.7467
`define sg13g2_lv_pmos_dphibl 1.1045
`define sg13g2_lv_pmos_dphibw -3.2860
`define sg13g2_lv_pmos_dphiblw 1.0000
`define sg13g2_lv_pmos_themuo 0.9150
`define sg13g2_lv_pmos_thesatl 0.8850
`define sg13g2_lv_pmos_thesatw 1.0337
`define sg13g2_lv_pmos_thesatlw 1.0000
`define sg13g2_lv_pmos_toxo 1.0200
`define sg13g2_lv_pmos_toxovo 1.0200
`define sg13g2_lv_pmos_cjorbot 1.0400
`define sg13g2_lv_pmos_cjorsti 1.0400
`define sg13g2_lv_pmos_cjorgat 1.0400
`define sg13g2_lv_svaricap_lap 1.041
`define sg13g2_lv_svaricap_toxo 1.02
`include "sg13g2_moslv_mod.va"
`endif
