//------------------------------------------------------------------------------
//
// Library:      SG13G2_dev
// Technologies: SG13G2
// Component:    Spice model file
//
// Simulator:    NGSPICE
// Model:        PSP 103.6
// Revision:     200310
//
//------------------------------------------------------------------------------
//
// Copyright 2023 IHP PDK Authors
//
// Licensed under the Apache License, Version 2.0 (the "License");
// you may not use this file except in compliance with the License.
// You may obtain a copy of the License at
//
//     https://www.apache.org/licenses/LICENSE-2.0
//
// Unless required by applicable law or agreed to in writing, software
// distributed under the License is distributed on an "AS IS" BASIS,
// WITHOUT WARRANTIES OR CONDITIONS OF ANY KIND, either express or implied.
// See the License for the specific language governing permissions and
// limitations under the License.
//
//------------------------------------------------------------------------------
//------------------------------------------------------------------------------
//
//
//                            M O S     C O R N E R S
//
//
//------------------------------------------------------------------------------
//
// NOTE: use only typical mean file (this file) for Monte Carlo simulations of process tolerance!
//
// hint: using spectre, add this file as a model file in analog artist;
//   using spectreS, add it under Environment/Include with syntax=spectre
//
// Corner naming scheme: typical mean=tt, worst case=ss, best case=ff, combinations sf, fs, ...
// Digit Devices

// Monte-Carlo begin ---------------------------------------------
//
// NOTE: default of all   parameters should be 1.0
// NOTE: deviations from 1.0 are used to fit statistical results
//
//
//
//
//------------------------------------------------------------------------------
//
// Low Voltage (lv) MOS Transistors
//
// Model:                                PSP 103.6
// Date:                                 10.03.2020
// Lot:                                  EDJ809
// WAFER:                                06
// CHIP Nr:                              x=3, y=9
// Device:                               SG13G2
// Maximum drain-source voltage:         1.5
// Measurement data:
// Nom. Temperature  (TNOM):             27 grd C
// Meas. Temperature (TEMP):             27 grd C
// Valid range for model:                L = (0.13 - 10)um
//                                       W = (0.15 - 10)um
//
//------------------------------------------------------------------------------

// Moslv corner modules
// Ported the ngspice/models/cornerMOSlv.lib to Verilog-A
// Modifications:
// - removed mismatch corners; mismatch device variants are implemented via
//   paramset overloading
// - moved global process-variation parameters from `sg13g2_moslv_stat.lib` to
//   into statistical corner-related definitions are kept in a single file
// - renamed the norm suffix to nom for nominal values for consitency across
//   corners
// (c) Lukas Deutz 2026

// **************** CORNER_LIB OF sg13g2_lv TT MODEL ****************
// Typical
module moslv_tt();
    // nmos
    localparam real sg13g2_lv_nmos_vfbo = 1.0;
    localparam real sg13g2_lv_nmos_ctl = 1.2080;
    localparam real sg13g2_lv_nmos_rsw1 = 0.7200;
    localparam real sg13g2_lv_nmos_muew = 0.8500;
    localparam real sg13g2_lv_nmos_dphibo = 0.9915;
    localparam real sg13g2_lv_nmos_dphibl = 0.9693;
    localparam real sg13g2_lv_nmos_dphibw = 0.9749;
    localparam real sg13g2_lv_nmos_dphiblw = 0.9754;
    localparam real sg13g2_lv_nmos_themuo = 0.8757;
    localparam real sg13g2_lv_nmos_thesatl = 0.7850;
    localparam real sg13g2_lv_nmos_thesatw = 1.5000;
    localparam real sg13g2_lv_nmos_thesatlw = 0.6127;
    localparam real sg13g2_lv_nmos_toxo = 1.0000;
    localparam real sg13g2_lv_nmos_toxovo = 1.0000;
    localparam real sg13g2_lv_nmos_cjorbot = 1.0000;
    localparam real sg13g2_lv_nmos_cjorsti = 1.0000;
    localparam real sg13g2_lv_nmos_cjorgat = 1.0000;
    // pmos
    localparam real sg13g2_lv_pmos_vfbo = 1.0;
    localparam real sg13g2_lv_pmos_ctl = 1.9570;
    localparam real sg13g2_lv_pmos_rsw1 = 0.7720;
    localparam real sg13g2_lv_pmos_muew = 1.0520;
    localparam real sg13g2_lv_pmos_dphibo = 0.9050;
    localparam real sg13g2_lv_pmos_dphibl = 0.8550;
    localparam real sg13g2_lv_pmos_dphibw = -1.5800;
    localparam real sg13g2_lv_pmos_dphiblw = 1.0000;
    localparam real sg13g2_lv_pmos_themuo = 0.9580;
    localparam real sg13g2_lv_pmos_thesatl = 0.5510;
    localparam real sg13g2_lv_pmos_thesatw = 1.0800;
    localparam real sg13g2_lv_pmos_thesatlw = 1.0000;
    localparam real sg13g2_lv_pmos_toxo = 1.0000;
    localparam real sg13g2_lv_pmos_toxovo = 1.0000;
    localparam real sg13g2_lv_pmos_cjorbot = 1.0000;
    localparam real sg13g2_lv_pmos_cjorsti = 1.0000;
    localparam real sg13g2_lv_pmos_cjorgat = 1.0000;
    // generic
    localparam real sg13g2_lv_svaricap_lap = 1.082;
    localparam real sg13g2_lv_svaricap_toxo = 1;
endmodule

// **************** CORNER_LIB OF sg13g2_lv SS MODEL ****************
// Slow n, Slow p
module moslv_ss();
    // nmos
    localparam real sg13g2_lv_nmos_vfbo = 1.0;
    localparam real sg13g2_lv_nmos_ctl = 0.4939;
    localparam real sg13g2_lv_nmos_rsw1 = 0.6560;
    localparam real sg13g2_lv_nmos_muew = 0.9700;
    localparam real sg13g2_lv_nmos_dphibo = 1.2070;
    localparam real sg13g2_lv_nmos_dphibl = 1.3360;
    localparam real sg13g2_lv_nmos_dphibw = 1.3290;
    localparam real sg13g2_lv_nmos_dphiblw = 1.0110;
    localparam real sg13g2_lv_nmos_themuo = 0.8866;
    localparam real sg13g2_lv_nmos_thesatl = 1.0960;
    localparam real sg13g2_lv_nmos_thesatw = 1.5930;
    localparam real sg13g2_lv_nmos_thesatlw = 0.9875;
    localparam real sg13g2_lv_nmos_toxo = 1.0400;
    localparam real sg13g2_lv_nmos_toxovo = 1.0400;
    localparam real sg13g2_lv_nmos_cjorbot = 1.0800;
    localparam real sg13g2_lv_nmos_cjorsti = 1.0800;
    localparam real sg13g2_lv_nmos_cjorgat = 1.0800;
    // pmos
    localparam real sg13g2_lv_pmos_vfbo = 1.0;
    localparam real sg13g2_lv_pmos_ctl = 1.3520;
    localparam real sg13g2_lv_pmos_rsw1 = 0.9365;
    localparam real sg13g2_lv_pmos_muew = 1.1030;
    localparam real sg13g2_lv_pmos_dphibo = 0.5883;
    localparam real sg13g2_lv_pmos_dphibl = 1.3540;
    localparam real sg13g2_lv_pmos_dphibw = -4.9920;
    localparam real sg13g2_lv_pmos_dphiblw = 1.0000;
    localparam real sg13g2_lv_pmos_themuo = 0.8720;
    localparam real sg13g2_lv_pmos_thesatl = 1.2190;
    localparam real sg13g2_lv_pmos_thesatw = 0.9875;
    localparam real sg13g2_lv_pmos_thesatlw = 1.0000;
    localparam real sg13g2_lv_pmos_toxo = 1.0400;
    localparam real sg13g2_lv_pmos_toxovo = 1.0400;
    localparam real sg13g2_lv_pmos_cjorbot = 1.0800;
    localparam real sg13g2_lv_pmos_cjorsti = 1.0800;
    localparam real sg13g2_lv_pmos_cjorgat = 1.0800;
    // generic
    localparam real sg13g2_lv_svaricap_lap = 1;
    localparam real sg13g2_lv_svaricap_toxo = 1.04;
endmodule

// **************** CORNER_LIB OF sg13g2_lv FF MODEL ****************
// Fast n, Fast p
module moslv_ff();
    // nmos
    localparam real sg13g2_lv_nmos_vfbo = 1.0;
    localparam real sg13g2_lv_nmos_ctl = 1.4310;
    localparam real sg13g2_lv_nmos_rsw1 = 0.9000;
    localparam real sg13g2_lv_nmos_muew = 0.7780;
    localparam real sg13g2_lv_nmos_dphibo = 0.8137;
    localparam real sg13g2_lv_nmos_dphibl = 0.6550;
    localparam real sg13g2_lv_nmos_dphibw = 0.6105;
    localparam real sg13g2_lv_nmos_dphiblw = 0.9300;
    localparam real sg13g2_lv_nmos_themuo = 0.8708;
    localparam real sg13g2_lv_nmos_thesatl = 0.5510;
    localparam real sg13g2_lv_nmos_thesatw = 1.4300;
    localparam real sg13g2_lv_nmos_thesatlw = 0.0860;
    localparam real sg13g2_lv_nmos_toxo = 0.9600;
    localparam real sg13g2_lv_nmos_toxovo = 0.9600;
    localparam real sg13g2_lv_nmos_cjorbot = 0.9200;
    localparam real sg13g2_lv_nmos_cjorsti = 0.9200;
    localparam real sg13g2_lv_nmos_cjorgat = 0.9200;
    // pmos
    localparam real sg13g2_lv_pmos_vfbo = 1.0;
    localparam real sg13g2_lv_pmos_ctl = 2.4800;
    localparam real sg13g2_lv_pmos_rsw1 = 0.5000;
    localparam real sg13g2_lv_pmos_muew = 0.9620;
    localparam real sg13g2_lv_pmos_dphibo = 1.2350;
    localparam real sg13g2_lv_pmos_dphibl = 0.5066;
    localparam real sg13g2_lv_pmos_dphibw = 3.9230;
    localparam real sg13g2_lv_pmos_dphiblw = 1.0000;
    localparam real sg13g2_lv_pmos_themuo = 1.0200;
    localparam real sg13g2_lv_pmos_thesatl = 0.1880;
    localparam real sg13g2_lv_pmos_thesatw = 1.2440;
    localparam real sg13g2_lv_pmos_thesatlw = 2.0000;
    localparam real sg13g2_lv_pmos_toxo = 0.9600;
    localparam real sg13g2_lv_pmos_toxovo = 0.9600;
    localparam real sg13g2_lv_pmos_cjorbot = 0.9200;
    localparam real sg13g2_lv_pmos_cjorsti = 0.9200;
    localparam real sg13g2_lv_pmos_cjorgat = 0.9200;
    // generic
    localparam real sg13g2_lv_svaricap_lap = 1.24;
    localparam real sg13g2_lv_svaricap_toxo = 0.96;
endmodule

// **************** CORNER_LIB OF sg13g2_lv SF MODEL ****************
// Slow n, Fast p
module moslv_sf();
    // nmos
    localparam real sg13g2_lv_nmos_vfbo = 1.0;
    localparam real sg13g2_lv_nmos_ctl = 0.8509;
    localparam real sg13g2_lv_nmos_rsw1 = 0.6880;
    localparam real sg13g2_lv_nmos_muew = 0.9100;
    localparam real sg13g2_lv_nmos_dphibo = 1.0993;
    localparam real sg13g2_lv_nmos_dphibl = 1.1526;
    localparam real sg13g2_lv_nmos_dphibw = 1.1520;
    localparam real sg13g2_lv_nmos_dphiblw = 0.9932;
    localparam real sg13g2_lv_nmos_themuo = 0.8812;
    localparam real sg13g2_lv_nmos_thesatl = 0.9405;
    localparam real sg13g2_lv_nmos_thesatw = 1.5465;
    localparam real sg13g2_lv_nmos_thesatlw = 0.8001;
    localparam real sg13g2_lv_nmos_toxo = 1.0200;
    localparam real sg13g2_lv_nmos_toxovo = 1.0200;
    localparam real sg13g2_lv_nmos_cjorbot = 1.0400;
    localparam real sg13g2_lv_nmos_cjorsti = 1.0400;
    localparam real sg13g2_lv_nmos_cjorgat = 1.0400;
    // pmos
    localparam real sg13g2_lv_pmos_vfbo = 1.0;
    localparam real sg13g2_lv_pmos_ctl = 2.2185;
    localparam real sg13g2_lv_pmos_rsw1 = 0.6360;
    localparam real sg13g2_lv_pmos_muew = 1.0070;
    localparam real sg13g2_lv_pmos_dphibo = 1.0700;
    localparam real sg13g2_lv_pmos_dphibl = 0.6808;
    localparam real sg13g2_lv_pmos_dphibw = 1.1715;
    localparam real sg13g2_lv_pmos_dphiblw = 1.0000;
    localparam real sg13g2_lv_pmos_themuo = 0.9890;
    localparam real sg13g2_lv_pmos_thesatl = 0.3695;
    localparam real sg13g2_lv_pmos_thesatw = 1.1620;
    localparam real sg13g2_lv_pmos_thesatlw = 1.5000;
    localparam real sg13g2_lv_pmos_toxo = 0.9800;
    localparam real sg13g2_lv_pmos_toxovo = 0.9800;
    localparam real sg13g2_lv_pmos_cjorbot = 0.9600;
    localparam real sg13g2_lv_pmos_cjorsti = 0.9600;
    localparam real sg13g2_lv_pmos_cjorgat = 0.9600;
    // generic
    localparam real sg13g2_lv_svaricap_lap = 1.161;
    localparam real sg13g2_lv_svaricap_toxo = 0.98;
endmodule

// **************** CORNER_LIB OF sg13g2_lv FS MODEL ****************
// Fast n, Slow p
module moslv_fs();
    // nmos
    localparam real sg13g2_lv_nmos_vfbo = 1.0;
    localparam real sg13g2_lv_nmos_ctl = 1.3195;
    localparam real sg13g2_lv_nmos_rsw1 = 0.8100;
    localparam real sg13g2_lv_nmos_muew = 0.8140;
    localparam real sg13g2_lv_nmos_dphibo = 0.9026;
    localparam real sg13g2_lv_nmos_dphibl = 0.8122;
    localparam real sg13g2_lv_nmos_dphibw = 0.7927;
    localparam real sg13g2_lv_nmos_dphiblw = 0.9527;
    localparam real sg13g2_lv_nmos_themuo = 0.8733;
    localparam real sg13g2_lv_nmos_thesatl = 0.6680;
    localparam real sg13g2_lv_nmos_thesatw = 1.4650;
    localparam real sg13g2_lv_nmos_thesatlw = 0.3493;
    localparam real sg13g2_lv_nmos_toxo = 0.9800;
    localparam real sg13g2_lv_nmos_toxovo = 0.9800;
    localparam real sg13g2_lv_nmos_cjorbot = 0.9600;
    localparam real sg13g2_lv_nmos_cjorsti = 0.9600;
    localparam real sg13g2_lv_nmos_cjorgat = 0.9600;
    // pmos
    localparam real sg13g2_lv_pmos_vfbo = 1.0;
    localparam real sg13g2_lv_pmos_ctl = 1.6545;
    localparam real sg13g2_lv_pmos_rsw1 = 0.8542;
    localparam real sg13g2_lv_pmos_muew = 1.0775;
    localparam real sg13g2_lv_pmos_dphibo = 0.7467;
    localparam real sg13g2_lv_pmos_dphibl = 1.1045;
    localparam real sg13g2_lv_pmos_dphibw = -3.2860;
    localparam real sg13g2_lv_pmos_dphiblw = 1.0000;
    localparam real sg13g2_lv_pmos_themuo = 0.9150;
    localparam real sg13g2_lv_pmos_thesatl = 0.8850;
    localparam real sg13g2_lv_pmos_thesatw = 1.0337;
    localparam real sg13g2_lv_pmos_thesatlw = 1.0000;
    localparam real sg13g2_lv_pmos_toxo = 1.0200;
    localparam real sg13g2_lv_pmos_toxovo = 1.0200;
    localparam real sg13g2_lv_pmos_cjorbot = 1.0400;
    localparam real sg13g2_lv_pmos_cjorsti = 1.0400;
    localparam real sg13g2_lv_pmos_cjorgat = 1.0400;
    // generic
    localparam real sg13g2_lv_svaricap_lap = 1.041;
    localparam real sg13g2_lv_svaricap_toxo = 1.02;
endmodule

// Typical with statistical
// one-sigma deviations (1/3 of min-max)
module moslv_tt_stat();
    parameter integer seed = 0 from [0:1000000); // TODO: inf for upper integer bounds not working
    // nmos nominal
    localparam real sg13g2_lv_nmos_vfbo_nom     = 1.0;
    localparam real sg13g2_lv_nmos_ctl_nom      = 1.2080;
    localparam real sg13g2_lv_nmos_rsw1_nom     = 0.7200;
    localparam real sg13g2_lv_nmos_muew_nom     = 0.8500;
    localparam real sg13g2_lv_nmos_dphibo_nom   = 0.9915;
    localparam real sg13g2_lv_nmos_dphibl_nom   = 0.9693;
    localparam real sg13g2_lv_nmos_dphibw_nom   = 0.9749;
    localparam real sg13g2_lv_nmos_dphiblw_nom  = 0.9754;
    localparam real sg13g2_lv_nmos_themuo_nom   = 0.8757;
    localparam real sg13g2_lv_nmos_thesatl_nom  = 0.7850;
    localparam real sg13g2_lv_nmos_thesatw_nom  = 1.5000;
    localparam real sg13g2_lv_nmos_thesatlw_nom = 0.6127;
    localparam real sg13g2_lv_nmos_toxo_nom     = 1.0000;
    localparam real sg13g2_lv_nmos_toxovo_nom   = 1.0000;
    localparam real sg13g2_lv_nmos_cjorbot_nom  = 1.0000;
    localparam real sg13g2_lv_nmos_cjorsti_nom  = 1.0000;
    localparam real sg13g2_lv_nmos_cjorgat_nom  = 1.0000;
    // nmos sigma
    localparam real sg13g2_lv_nmos_vfbo_sig     = 0.0050 * sg13g2_lv_nmos_vfbo_nom;
    localparam real sg13g2_lv_nmos_ctl_sig      = 0.1562 * sg13g2_lv_nmos_ctl_nom;
    localparam real sg13g2_lv_nmos_rsw1_sig     = 0.0407 * sg13g2_lv_nmos_rsw1_nom;
    localparam real sg13g2_lv_nmos_muew_sig     = 0.0320 * sg13g2_lv_nmos_muew_nom;
    localparam real sg13g2_lv_nmos_dphibo_sig   = 0.0656 * sg13g2_lv_nmos_dphibo_nom;
    localparam real sg13g2_lv_nmos_dphibl_sig   = 0.1135 * sg13g2_lv_nmos_dphibl_nom;
    localparam real sg13g2_lv_nmos_dphibw_sig   = 0.1197 * sg13g2_lv_nmos_dphibw_nom;
    localparam real sg13g2_lv_nmos_dphiblw_sig  = 0.0135 * sg13g2_lv_nmos_dphiblw_nom;
    localparam real sg13g2_lv_nmos_themuo_sig   = 0.0026 * sg13g2_lv_nmos_themuo_nom;
    localparam real sg13g2_lv_nmos_thesatl_sig  = 0.0908 * sg13g2_lv_nmos_thesatl_nom;
    localparam real sg13g2_lv_nmos_thesatw_sig  = 0.0272 * sg13g2_lv_nmos_thesatw_nom;
    localparam real sg13g2_lv_nmos_thesatlw_sig = 0.1503 * sg13g2_lv_nmos_thesatlw_nom;
    localparam real sg13g2_lv_nmos_toxo_sig     = 0.0133 * sg13g2_lv_nmos_toxo_nom;
    localparam real sg13g2_lv_nmos_toxovo_sig   = 0.0133 * sg13g2_lv_nmos_toxovo_nom;
    localparam real sg13g2_lv_nmos_cjorbot_sig  = 0.0267 * sg13g2_lv_nmos_cjorbot_nom;
    localparam real sg13g2_lv_nmos_cjorsti_sig  = 0.0267 * sg13g2_lv_nmos_cjorsti_nom;
    localparam real sg13g2_lv_nmos_cjorgat_sig  = 0.0267 * sg13g2_lv_nmos_cjorgat_nom;
    // nmos params with global process variation
    localparam real sg13g2_lv_nmos_vfbo     = sg13g2_lv_nmos_vfbo_nom     + $rdist_normal(seed + 1,  0, sg13g2_lv_nmos_vfbo_sig,     "global");
    localparam real sg13g2_lv_nmos_ctl      = sg13g2_lv_nmos_ctl_nom      + $rdist_normal(seed + 2,  0, sg13g2_lv_nmos_ctl_sig,      "global");
    localparam real sg13g2_lv_nmos_rsw1     = sg13g2_lv_nmos_rsw1_nom     + $rdist_normal(seed + 3,  0, sg13g2_lv_nmos_rsw1_sig,     "global");
    localparam real sg13g2_lv_nmos_muew     = sg13g2_lv_nmos_muew_nom     + $rdist_normal(seed + 4,  0, sg13g2_lv_nmos_muew_sig,     "global");
    localparam real sg13g2_lv_nmos_dphibo   = sg13g2_lv_nmos_dphibo_nom   + $rdist_normal(seed + 5,  0, sg13g2_lv_nmos_dphibo_sig,   "global");
    localparam real sg13g2_lv_nmos_dphibl   = sg13g2_lv_nmos_dphibl_nom   + $rdist_normal(seed + 6,  0, sg13g2_lv_nmos_dphibl_sig,   "global");
    localparam real sg13g2_lv_nmos_dphibw   = sg13g2_lv_nmos_dphibw_nom   + $rdist_normal(seed + 7,  0, sg13g2_lv_nmos_dphibw_sig,   "global");
    localparam real sg13g2_lv_nmos_dphiblw  = sg13g2_lv_nmos_dphiblw_nom  + $rdist_normal(seed + 8,  0, sg13g2_lv_nmos_dphiblw_sig,  "global");
    localparam real sg13g2_lv_nmos_themuo   = sg13g2_lv_nmos_themuo_nom   + $rdist_normal(seed + 9,  0, sg13g2_lv_nmos_themuo_sig,   "global");
    localparam real sg13g2_lv_nmos_thesatl  = sg13g2_lv_nmos_thesatl_nom  + $rdist_normal(seed + 10, 0, sg13g2_lv_nmos_thesatl_sig,  "global");
    localparam real sg13g2_lv_nmos_thesatw  = sg13g2_lv_nmos_thesatw_nom  + $rdist_normal(seed + 11, 0, sg13g2_lv_nmos_thesatw_sig,  "global");
    localparam real sg13g2_lv_nmos_thesatlw = sg13g2_lv_nmos_thesatlw_nom + $rdist_normal(seed + 12, 0, sg13g2_lv_nmos_thesatlw_sig, "global");
    localparam real sg13g2_lv_nmos_toxo     = sg13g2_lv_nmos_toxo_nom     + $rdist_normal(seed + 13, 0, sg13g2_lv_nmos_toxo_sig,     "global");
    localparam real sg13g2_lv_nmos_toxovo   = sg13g2_lv_nmos_toxovo_nom   + $rdist_normal(seed + 14, 0, sg13g2_lv_nmos_toxovo_sig,   "global");
    localparam real sg13g2_lv_nmos_cjorbot  = sg13g2_lv_nmos_cjorbot_nom  + $rdist_normal(seed + 14, 0, sg13g2_lv_nmos_cjorbot_sig,  "global");
    localparam real sg13g2_lv_nmos_cjorsti  = sg13g2_lv_nmos_cjorsti_nom  + $rdist_normal(seed + 15, 0, sg13g2_lv_nmos_cjorsti_sig,  "global");
    localparam real sg13g2_lv_nmos_cjorgat  = sg13g2_lv_nmos_cjorgat_nom  + $rdist_normal(seed + 16, 0, sg13g2_lv_nmos_cjorgat_sig,  "global");
    // pmos nominal
    localparam real sg13g2_lv_pmos_vfbo_nom     = 1.0;
    localparam real sg13g2_lv_pmos_ctl_nom      = 1.9570;
    localparam real sg13g2_lv_pmos_rsw1_nom     = 0.7720;
    localparam real sg13g2_lv_pmos_muew_nom     = 1.0520;
    localparam real sg13g2_lv_pmos_dphibo_nom   = 0.9050;
    localparam real sg13g2_lv_pmos_dphibl_nom   = 0.8550;
    localparam real sg13g2_lv_pmos_dphibw_nom   = -1.5800;
    localparam real sg13g2_lv_pmos_dphiblw_nom  = 1.0000;
    localparam real sg13g2_lv_pmos_themuo_nom   = 0.9580;
    localparam real sg13g2_lv_pmos_thesatl_nom  = 0.5510;
    localparam real sg13g2_lv_pmos_thesatw_nom  = 1.0800;
    localparam real sg13g2_lv_pmos_thesatlw_nom = 1.0000;
    localparam real sg13g2_lv_pmos_toxo_nom     = 1.0000;
    localparam real sg13g2_lv_pmos_toxovo_nom   = 1.0000;
    localparam real sg13g2_lv_pmos_cjorbot_nom  = 1.0000;
    localparam real sg13g2_lv_pmos_cjorsti_nom  = 1.0000;
    localparam real sg13g2_lv_pmos_cjorgat_nom  = 1.0000;
    // pmos sigma
    localparam real sg13g2_lv_pmos_vfbo_sig     = 0.0050 * sg13g2_lv_pmos_vfbo_nom;
    localparam real sg13g2_lv_pmos_ctl_sig      = 0.1880 * sg13g2_lv_pmos_ctl_nom;
    localparam real sg13g2_lv_pmos_rsw1_sig     = 0.0727 * sg13g2_lv_pmos_rsw1_nom;
    localparam real sg13g2_lv_pmos_muew_sig     = 0.0235 * sg13g2_lv_pmos_muew_nom;
    localparam real sg13g2_lv_pmos_dphibo_sig   = 0.1078 * sg13g2_lv_pmos_dphibo_nom;
    localparam real sg13g2_lv_pmos_dphibl_sig   = 0.1412 * sg13g2_lv_pmos_dphibl_nom;
    localparam real sg13g2_lv_pmos_dphibw_sig   = 1.4858 * sg13g2_lv_pmos_dphibw_nom;
    localparam real sg13g2_lv_pmos_dphiblw_sig  = 1.0e-9 * sg13g2_lv_pmos_dphiblw_nom;
    localparam real sg13g2_lv_pmos_themuo_sig   = 0.0247 * sg13g2_lv_pmos_themuo_nom;
    localparam real sg13g2_lv_pmos_thesatl_sig  = 0.1718 * sg13g2_lv_pmos_thesatl_nom;
    localparam real sg13g2_lv_pmos_thesatw_sig  = 0.0427 * sg13g2_lv_pmos_thesatw_nom;
    localparam real sg13g2_lv_pmos_thesatlw_sig = 0.1667 * sg13g2_lv_pmos_thesatlw_nom;
    localparam real sg13g2_lv_pmos_toxo_sig     = 0.0133 * sg13g2_lv_pmos_toxo_nom;
    localparam real sg13g2_lv_pmos_toxovo_sig   = 0.0133 * sg13g2_lv_pmos_toxovo_nom;
    localparam real sg13g2_lv_pmos_cjorbot_sig  = 0.0267 * sg13g2_lv_pmos_cjorbot_nom;
    localparam real sg13g2_lv_pmos_cjorsti_sig  = 0.0267 * sg13g2_lv_pmos_cjorsti_nom;
    localparam real sg13g2_lv_pmos_cjorgat_sig  = 0.0267 * sg13g2_lv_pmos_cjorgat_nom;
    // pmos params with global process variation
    localparam real sg13g2_lv_pmos_vfbo     = sg13g2_lv_pmos_vfbo_nom     + $rdist_normal(seed + 17, 0, sg13g2_lv_pmos_vfbo_sig,     "global");
    localparam real sg13g2_lv_pmos_ctl      = sg13g2_lv_pmos_ctl_nom      + $rdist_normal(seed + 18, 0, sg13g2_lv_pmos_ctl_sig,      "global");
    localparam real sg13g2_lv_pmos_rsw1     = sg13g2_lv_pmos_rsw1_nom     + $rdist_normal(seed + 19, 0, sg13g2_lv_pmos_rsw1_sig,     "global");
    localparam real sg13g2_lv_pmos_muew     = sg13g2_lv_pmos_muew_nom     + $rdist_normal(seed + 20, 0, sg13g2_lv_pmos_muew_sig,     "global");
    localparam real sg13g2_lv_pmos_dphibo   = sg13g2_lv_pmos_dphibo_nom   + $rdist_normal(seed + 21, 0, sg13g2_lv_pmos_dphibo_sig,   "global");
    localparam real sg13g2_lv_pmos_dphibl   = sg13g2_lv_pmos_dphibl_nom   + $rdist_normal(seed + 22, 0, sg13g2_lv_pmos_dphibl_sig,   "global");
    localparam real sg13g2_lv_pmos_dphibw   = sg13g2_lv_pmos_dphibw_nom   + $rdist_normal(seed + 23, 0, sg13g2_lv_pmos_dphibw_sig,   "global");
    localparam real sg13g2_lv_pmos_dphiblw  = sg13g2_lv_pmos_dphiblw_nom  + $rdist_normal(seed + 24, 0, sg13g2_lv_pmos_dphiblw_sig,  "global");
    localparam real sg13g2_lv_pmos_themuo   = sg13g2_lv_pmos_themuo_nom   + $rdist_normal(seed + 25, 0, sg13g2_lv_pmos_themuo_sig,   "global");
    localparam real sg13g2_lv_pmos_thesatl  = sg13g2_lv_pmos_thesatl_nom  + $rdist_normal(seed + 26, 0, sg13g2_lv_pmos_thesatl_sig,  "global");
    localparam real sg13g2_lv_pmos_thesatw  = sg13g2_lv_pmos_thesatw_nom  + $rdist_normal(seed + 27, 0, sg13g2_lv_pmos_thesatw_sig,  "global");
    localparam real sg13g2_lv_pmos_thesatlw = sg13g2_lv_pmos_thesatlw_nom + $rdist_normal(seed + 28, 0, sg13g2_lv_pmos_thesatlw_sig, "global");
    localparam real sg13g2_lv_pmos_toxo     = sg13g2_lv_pmos_toxo_nom     + $rdist_normal(seed + 29, 0, sg13g2_lv_pmos_toxo_sig,     "global");
    localparam real sg13g2_lv_pmos_toxovo   = sg13g2_lv_pmos_toxovo_nom   + $rdist_normal(seed + 30, 0, sg13g2_lv_pmos_toxovo_sig,   "global");
    localparam real sg13g2_lv_pmos_cjorbot  = sg13g2_lv_pmos_cjorbot_nom  + $rdist_normal(seed + 31, 0, sg13g2_lv_pmos_cjorbot_sig,  "global");
    localparam real sg13g2_lv_pmos_cjorsti  = sg13g2_lv_pmos_cjorsti_nom  + $rdist_normal(seed + 32, 0, sg13g2_lv_pmos_cjorsti_sig,  "global");
    localparam real sg13g2_lv_pmos_cjorgat  = sg13g2_lv_pmos_cjorgat_nom  + $rdist_normal(seed + 33, 0, sg13g2_lv_pmos_cjorgat_sig,  "global");
    // general
    localparam real sg13g2_lv_svaricap_lap = 1.082;
    localparam real sg13g2_lv_svaricap_toxo = 1;
endmodule

// TODO: mm params are hard coded into paramsets, pull out of module instead?
module moslv_mm();
    // nmos
    localparam real sg13g2_lv_nmos_delvto_mm  = 0.0039;
    localparam real sg13g2_lv_nmos_factuo_mm  = 0.005;
    localparam real sg13g2_lv_nmos_dw_mm      = 4e-9;
    localparam real sg13g2_lv_nmos_dl_mm      = 2e-9;
    // pmos
    localparam real sg13g2_lv_pmos_delvto_mm  = 0.0022;
    localparam real sg13g2_lv_pmos_factuo_mm  = 0.0033;
    localparam real sg13g2_lv_pmos_dw_mm      = 4e-9;
    localparam real sg13g2_lv_pmos_dl_mm      = 2e-9;
endmodule
