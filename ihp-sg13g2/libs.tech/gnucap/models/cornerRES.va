`include "disciplines.vams"

`ifdef res_typ
`define rsh_rhigh 1360
`define rsh_rppd 260.0
`define rsh_rsil 7.0
`define res_area 1.0
`define res_rpara 1.0
`include "resistors_mod.va"
`endif

`ifdef res_typ_stat
`define rsh_rhigh_norm 1360
`define rsh_rppd_norm 260.0
`define rsh_rsil_norm 7.0
`define res_area_norm 1.0
`define res_rpara_norm 1.0
`include "resistors_stat.va"
`include "resistors_mod.va"
`endif

`ifdef res_bcs
`define rsh_rhigh 1020
`define rsh_rppd 234.0
`define rsh_rsil 6.02
`define res_area 1.0
`define res_rpara 1.0
`include "resistors_mod.va"
`endif

`ifdef res_wcs
`define rsh_rhigh 1700
`define rsh_rppd 286.0
`define rsh_rsil 7.98
`define res_area 1.0
`define res_rpara 1.0
`include "resistors_mod.va"
`endif
