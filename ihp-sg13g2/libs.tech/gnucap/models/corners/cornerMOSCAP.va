//******************************************************************************
//                                                                             *
// Library:      SG13G2_dev                                                    *
// Technologies: SG13G2                                                        *
// Component:    Spice model file                                              *
//                                                                             *
// Simulator:    NGSPICE                                                       *
// Model:        PSP 103.6                                                     *
// Revision:     210511                                                        *
//                                                                             *
//******************************************************************************
//                                                                             *
// Copyright 2026 IHP PDK Authors                                              *
//                                                                             *
// Licensed under the Apache License, Version 2.0 (the "License");             *
// you may not use this file except in compliance with the License.            *
// You may obtain a copy of the License at                                     *
//                                                                             *
//     https://www.apache.org/licenses/LICENSE-2.0                             *
//                                                                             *
// Unless required by applicable law or agreed to in writing, software         *
// distributed under the License is distributed on an "AS IS" BASIS,           *
// WITHOUT WARRANTIES OR CONDITIONS OF ANY KIND, either express or implied.    *
// See the License for the specific language governing permissions and         *
// limitations under the License.                                              *
//                                                                             *
//******************************************************************************
//******************************************************************************
//                                                                             *
//                                                                             *
//                      M O S C A P   C O R N E R S                            *
//                                                                             *
//                                                                             *
//******************************************************************************
//
// NOTE: use only typical mean file (this file) for Monte Carlo simulations of process tolerance!
//
// MOS capacitors use the low-voltage MOS PSP103 model cards with dedicated
// two-terminal MOSCAP subcircuits.  Keep this corner entry point separate from
// cornerMOSlv.va so MOSCAP users do not include MOS transistor wrappers.
//
// Corner naming scheme: typical mean=tt, worst case=ss, best case=ff, combinations sf, fs, ...
// Monte-Carlo begin ---------------------------------------------
//
// NOTE: default of all   parameters should be 1.0
// NOTE: deviations from 1.0 are used to fit statistical results
//
//******************************************************************************

//******************************************************************************
// MOSCAP corner modules
//
// Adapted from `ngspice/models/cornerMOSCAP.lib`
//
// Modifications:
// - Mismatch corners removed; mismatch device variants use paramset overloading
// - Moved global process-variation parameters into statistical corner
// - Use nom suffix instead of norm for consistency
// - Dropped num_sigmas parameter
//******************************************************************************

// TODO: Enable include guards once Gnucap runtime Verilog loading supports preprocessing.
// `ifndef SG13G2_CORNER_MOSCAP_VA
// `define SG13G2_CORNER_MOSCAP_VA

//*************** CORNER_LIB OF sg13g2 MOSCAP TT MODEL ****************

(* desc = "typical MOSCAP corner" *)
module moscap_tt();
    // nmos
    localparam real sg13g2_moscap_n_vfbo    = 1.0;
    localparam real sg13g2_moscap_n_ctl     = 1.2080;
    localparam real sg13g2_moscap_n_rsw1    = 0.7200;
    localparam real sg13g2_moscap_n_muew    = 0.8500;
    localparam real sg13g2_moscap_n_dphibo  = 0.9915;
    localparam real sg13g2_moscap_n_dphibl  = 0.9693;
    localparam real sg13g2_moscap_n_dphibw  = 0.9749;
    localparam real sg13g2_moscap_n_dphiblw = 0.9754;
    localparam real sg13g2_moscap_n_themuo  = 0.8757;
    localparam real sg13g2_moscap_n_thesatl = 0.7850;
    localparam real sg13g2_moscap_n_thesatw = 1.5000;
    localparam real sg13g2_moscap_n_thesatlw= 0.6127;
    localparam real sg13g2_moscap_n_toxo    = 1.0000;
    localparam real sg13g2_moscap_n_toxovo  = 1.0000;
    localparam real sg13g2_moscap_n_cjorbot = 1.0000;
    localparam real sg13g2_moscap_n_cjorsti = 1.0000;
    localparam real sg13g2_moscap_n_cjorgat = 1.0000;
    // pmos
    localparam real sg13g2_moscap_p_vfbo    = 1.0;
    localparam real sg13g2_moscap_p_ctl     = 1.9570;
    localparam real sg13g2_moscap_p_rsw1    = 0.7720;
    localparam real sg13g2_moscap_p_muew    = 1.0520;
    localparam real sg13g2_moscap_p_dphibo  = 0.9050;
    localparam real sg13g2_moscap_p_dphibl  = 0.8550;
    localparam real sg13g2_moscap_p_dphibw  = -1.5800;
    localparam real sg13g2_moscap_p_dphiblw = 1.0000;
    localparam real sg13g2_moscap_p_themuo  = 0.9580;
    localparam real sg13g2_moscap_p_thesatl = 0.5510;
    localparam real sg13g2_moscap_p_thesatw = 1.0800;
    localparam real sg13g2_moscap_p_thesatlw= 1.0000;
    localparam real sg13g2_moscap_p_toxo    = 1.0000;
    localparam real sg13g2_moscap_p_toxovo  = 1.0000;
    localparam real sg13g2_moscap_p_cjorbot = 1.0000;
    localparam real sg13g2_moscap_p_cjorsti = 1.0000;
    localparam real sg13g2_moscap_p_cjorgat = 1.0000;
endmodule

(* desc = "statistical MOSCAP corner" *)
module moscap_tt_stat();
    parameter integer seed = 1;
    // nmos nominal
    localparam real sg13g2_moscap_n_vfbo_nom    = 1.0;
    localparam real sg13g2_moscap_n_ctl_nom     = 1.2080;
    localparam real sg13g2_moscap_n_rsw1_nom    = 0.7200;
    localparam real sg13g2_moscap_n_muew_nom    = 0.8500;
    localparam real sg13g2_moscap_n_dphibo_nom  = 0.9915;
    localparam real sg13g2_moscap_n_dphibl_nom  = 0.9693;
    localparam real sg13g2_moscap_n_dphibw_nom  = 0.9749;
    localparam real sg13g2_moscap_n_dphiblw_nom = 0.9754;
    localparam real sg13g2_moscap_n_themuo_nom  = 0.8757;
    localparam real sg13g2_moscap_n_thesatl_nom = 0.7850;
    localparam real sg13g2_moscap_n_thesatw_nom = 1.5000;
    localparam real sg13g2_moscap_n_thesatlw_nom= 0.6127;
    localparam real sg13g2_moscap_n_toxo_nom    = 1.0000;
    localparam real sg13g2_moscap_n_toxovo_nom  = 1.0000;
    localparam real sg13g2_moscap_n_cjorbot_nom = 1.0000;
    localparam real sg13g2_moscap_n_cjorsti_nom = 1.0000;
    localparam real sg13g2_moscap_n_cjorgat_nom = 1.0000;
    // nmos sig
    localparam real sg13g2_moscap_n_vfbo_sig    = 0.0050 * abs(sg13g2_moscap_n_vfbo_nom);
    localparam real sg13g2_moscap_n_ctl_sig     = 0.1562 * abs(sg13g2_moscap_n_ctl_nom);
    localparam real sg13g2_moscap_n_rsw1_sig    = 0.0407 * abs(sg13g2_moscap_n_rsw1_nom);
    localparam real sg13g2_moscap_n_muew_sig    = 0.0320 * abs(sg13g2_moscap_n_muew_nom);
    localparam real sg13g2_moscap_n_dphibo_sig  = 0.0656 * abs(sg13g2_moscap_n_dphibo_nom);
    localparam real sg13g2_moscap_n_dphibl_sig  = 0.1135 * abs(sg13g2_moscap_n_dphibl_nom);
    localparam real sg13g2_moscap_n_dphibw_sig  = 0.1197 * abs(sg13g2_moscap_n_dphibw_nom);
    localparam real sg13g2_moscap_n_dphiblw_sig = 0.0135 * abs(sg13g2_moscap_n_dphiblw_nom);
    localparam real sg13g2_moscap_n_themuo_sig  = 0.0026 * abs(sg13g2_moscap_n_themuo_nom);
    localparam real sg13g2_moscap_n_thesatl_sig = 0.0908 * abs(sg13g2_moscap_n_thesatl_nom);
    localparam real sg13g2_moscap_n_thesatw_sig = 0.0272 * abs(sg13g2_moscap_n_thesatw_nom);
    localparam real sg13g2_moscap_n_thesatlw_sig= 0.1503 * abs(sg13g2_moscap_n_thesatlw_nom);
    localparam real sg13g2_moscap_n_toxo_sig    = 0.0133 * abs(sg13g2_moscap_n_toxo_nom);
    localparam real sg13g2_moscap_n_toxovo_sig  = 0.0133 * abs(sg13g2_moscap_n_toxovo_nom);
    localparam real sg13g2_moscap_n_cjorbot_sig = 0.0267 * abs(sg13g2_moscap_n_cjorbot_nom);
    localparam real sg13g2_moscap_n_cjorsti_sig = 0.0267 * abs(sg13g2_moscap_n_cjorsti_nom);
    localparam real sg13g2_moscap_n_cjorgat_sig = 0.0267 * abs(sg13g2_moscap_n_cjorgat_nom);
    // nmos params with global process variation
    localparam real sg13g2_moscap_n_vfbo    = $rdist_normal(seed + 1,  sg13g2_moscap_n_vfbo_nom,     sg13g2_moscap_n_vfbo_sig,     "global");
    localparam real sg13g2_moscap_n_ctl     = $rdist_normal(seed + 2,  sg13g2_moscap_n_ctl_nom,      sg13g2_moscap_n_ctl_sig,      "global");
    localparam real sg13g2_moscap_n_rsw1    = $rdist_normal(seed + 3,  sg13g2_moscap_n_rsw1_nom,     sg13g2_moscap_n_rsw1_sig,     "global");
    localparam real sg13g2_moscap_n_muew    = $rdist_normal(seed + 4,  sg13g2_moscap_n_muew_nom,     sg13g2_moscap_n_muew_sig,     "global");
    localparam real sg13g2_moscap_n_dphibo  = $rdist_normal(seed + 5,  sg13g2_moscap_n_dphibo_nom,   sg13g2_moscap_n_dphibo_sig,   "global");
    localparam real sg13g2_moscap_n_dphibl  = $rdist_normal(seed + 6,  sg13g2_moscap_n_dphibl_nom,   sg13g2_moscap_n_dphibl_sig,   "global");
    localparam real sg13g2_moscap_n_dphibw  = $rdist_normal(seed + 7,  sg13g2_moscap_n_dphibw_nom,   sg13g2_moscap_n_dphibw_sig,   "global");
    localparam real sg13g2_moscap_n_dphiblw = $rdist_normal(seed + 8,  sg13g2_moscap_n_dphiblw_nom,  sg13g2_moscap_n_dphiblw_sig,  "global");
    localparam real sg13g2_moscap_n_themuo  = $rdist_normal(seed + 9,  sg13g2_moscap_n_themuo_nom,   sg13g2_moscap_n_themuo_sig,   "global");
    localparam real sg13g2_moscap_n_thesatl = $rdist_normal(seed + 10, sg13g2_moscap_n_thesatl_nom,  sg13g2_moscap_n_thesatl_sig,  "global");
    localparam real sg13g2_moscap_n_thesatw = $rdist_normal(seed + 11, sg13g2_moscap_n_thesatw_nom,  sg13g2_moscap_n_thesatw_sig,  "global");
    localparam real sg13g2_moscap_n_thesatlw= $rdist_normal(seed + 12, sg13g2_moscap_n_thesatlw_nom, sg13g2_moscap_n_thesatlw_sig, "global");
    localparam real sg13g2_moscap_n_toxo    = $rdist_normal(seed + 13, sg13g2_moscap_n_toxo_nom,     sg13g2_moscap_n_toxo_sig,     "global");
    localparam real sg13g2_moscap_n_toxovo  = $rdist_normal(seed + 14, sg13g2_moscap_n_toxovo_nom,   sg13g2_moscap_n_toxovo_sig,   "global");
    localparam real sg13g2_moscap_n_cjorbot = $rdist_normal(seed + 15, sg13g2_moscap_n_cjorbot_nom,  sg13g2_moscap_n_cjorbot_sig,  "global");
    localparam real sg13g2_moscap_n_cjorsti = $rdist_normal(seed + 16, sg13g2_moscap_n_cjorsti_nom,  sg13g2_moscap_n_cjorsti_sig,  "global");
    localparam real sg13g2_moscap_n_cjorgat = $rdist_normal(seed + 17, sg13g2_moscap_n_cjorgat_nom,  sg13g2_moscap_n_cjorgat_sig,  "global");
    // pmos nominal parameter values
    localparam real sg13g2_moscap_p_vfbo_nom    = 1.0;
    localparam real sg13g2_moscap_p_ctl_nom     = 1.9570;
    localparam real sg13g2_moscap_p_rsw1_nom    = 0.7720;
    localparam real sg13g2_moscap_p_muew_nom    = 1.0520;
    localparam real sg13g2_moscap_p_dphibo_nom  = 0.9050;
    localparam real sg13g2_moscap_p_dphibl_nom  = 0.8550;
    localparam real sg13g2_moscap_p_dphibw_nom  = -1.5800;
    localparam real sg13g2_moscap_p_dphiblw_nom = 1.0000;
    localparam real sg13g2_moscap_p_themuo_nom  = 0.9580;
    localparam real sg13g2_moscap_p_thesatl_nom = 0.5510;
    localparam real sg13g2_moscap_p_thesatw_nom = 1.0800;
    localparam real sg13g2_moscap_p_thesatlw_nom= 1.0000;
    localparam real sg13g2_moscap_p_toxo_nom    = 1.0000;
    localparam real sg13g2_moscap_p_toxovo_nom  = 1.0000;
    localparam real sg13g2_moscap_p_cjorbot_nom = 1.0000;
    localparam real sg13g2_moscap_p_cjorsti_nom = 1.0000;
    localparam real sg13g2_moscap_p_cjorgat_nom = 1.0000;
    // pmos sig
    localparam real sg13g2_moscap_p_vfbo_sig    = 0.0050 * abs(sg13g2_moscap_p_vfbo_nom);
    localparam real sg13g2_moscap_p_ctl_sig     = 0.1880 * abs(sg13g2_moscap_p_ctl_nom);
    localparam real sg13g2_moscap_p_rsw1_sig    = 0.0727 * abs(sg13g2_moscap_p_rsw1_nom);
    localparam real sg13g2_moscap_p_muew_sig    = 0.0235 * abs(sg13g2_moscap_p_muew_nom);
    localparam real sg13g2_moscap_p_dphibo_sig  = 0.1078 * abs(sg13g2_moscap_p_dphibo_nom);
    localparam real sg13g2_moscap_p_dphibl_sig  = 0.1412 * abs(sg13g2_moscap_p_dphibl_nom);
    localparam real sg13g2_moscap_p_dphibw_sig  = 1.4858 * abs(sg13g2_moscap_p_dphibw_nom);
    localparam real sg13g2_moscap_p_dphiblw_sig = 1.0e-9 * abs(sg13g2_moscap_p_dphiblw_nom);
    localparam real sg13g2_moscap_p_themuo_sig  = 0.0247 * abs(sg13g2_moscap_p_themuo_nom);
    localparam real sg13g2_moscap_p_thesatl_sig = 0.1718 * abs(sg13g2_moscap_p_thesatl_nom);
    localparam real sg13g2_moscap_p_thesatw_sig = 0.0427 * abs(sg13g2_moscap_p_thesatw_nom);
    localparam real sg13g2_moscap_p_thesatlw_sig= 0.1667 * abs(sg13g2_moscap_p_thesatlw_nom);
    localparam real sg13g2_moscap_p_toxo_sig    = 0.0133 * abs(sg13g2_moscap_p_toxo_nom);
    localparam real sg13g2_moscap_p_toxovo_sig  = 0.0133 * abs(sg13g2_moscap_p_toxovo_nom);
    localparam real sg13g2_moscap_p_cjorbot_sig = 0.0267 * abs(sg13g2_moscap_p_cjorbot_nom);
    localparam real sg13g2_moscap_p_cjorsti_sig = 0.0267 * abs(sg13g2_moscap_p_cjorsti_nom);
    localparam real sg13g2_moscap_p_cjorgat_sig = 0.0267 * abs(sg13g2_moscap_p_cjorgat_nom);
    // pmos params with global process variation
    localparam real sg13g2_moscap_p_vfbo    = $rdist_normal(seed + 18, sg13g2_moscap_p_vfbo_nom,     sg13g2_moscap_p_vfbo_sig,     "global");
    localparam real sg13g2_moscap_p_ctl     = $rdist_normal(seed + 19, sg13g2_moscap_p_ctl_nom,      sg13g2_moscap_p_ctl_sig,      "global");
    localparam real sg13g2_moscap_p_rsw1    = $rdist_normal(seed + 20, sg13g2_moscap_p_rsw1_nom,     sg13g2_moscap_p_rsw1_sig,     "global");
    localparam real sg13g2_moscap_p_muew    = $rdist_normal(seed + 21, sg13g2_moscap_p_muew_nom,     sg13g2_moscap_p_muew_sig,     "global");
    localparam real sg13g2_moscap_p_dphibo  = $rdist_normal(seed + 22, sg13g2_moscap_p_dphibo_nom,   sg13g2_moscap_p_dphibo_sig,   "global");
    localparam real sg13g2_moscap_p_dphibl  = $rdist_normal(seed + 23, sg13g2_moscap_p_dphibl_nom,   sg13g2_moscap_p_dphibl_sig,   "global");
    localparam real sg13g2_moscap_p_dphibw  = $rdist_normal(seed + 24, sg13g2_moscap_p_dphibw_nom,   sg13g2_moscap_p_dphibw_sig,   "global");
    localparam real sg13g2_moscap_p_dphiblw = $rdist_normal(seed + 25, sg13g2_moscap_p_dphiblw_nom,  sg13g2_moscap_p_dphiblw_sig,  "global");
    localparam real sg13g2_moscap_p_themuo  = $rdist_normal(seed + 26, sg13g2_moscap_p_themuo_nom,   sg13g2_moscap_p_themuo_sig,   "global");
    localparam real sg13g2_moscap_p_thesatl = $rdist_normal(seed + 27, sg13g2_moscap_p_thesatl_nom,  sg13g2_moscap_p_thesatl_sig,  "global");
    localparam real sg13g2_moscap_p_thesatw = $rdist_normal(seed + 28, sg13g2_moscap_p_thesatw_nom,  sg13g2_moscap_p_thesatw_sig,  "global");
    localparam real sg13g2_moscap_p_thesatlw= $rdist_normal(seed + 29, sg13g2_moscap_p_thesatlw_nom, sg13g2_moscap_p_thesatlw_sig, "global");
    localparam real sg13g2_moscap_p_toxo    = $rdist_normal(seed + 30, sg13g2_moscap_p_toxo_nom,     sg13g2_moscap_p_toxo_sig,     "global");
    localparam real sg13g2_moscap_p_toxovo  = $rdist_normal(seed + 31, sg13g2_moscap_p_toxovo_nom,   sg13g2_moscap_p_toxovo_sig,   "global");
    localparam real sg13g2_moscap_p_cjorbot = $rdist_normal(seed + 32, sg13g2_moscap_p_cjorbot_nom,  sg13g2_moscap_p_cjorbot_sig,  "global");
    localparam real sg13g2_moscap_p_cjorsti = $rdist_normal(seed + 33, sg13g2_moscap_p_cjorsti_nom,  sg13g2_moscap_p_cjorsti_sig,  "global");
    localparam real sg13g2_moscap_p_cjorgat = $rdist_normal(seed + 34, sg13g2_moscap_p_cjorgat_nom,  sg13g2_moscap_p_cjorgat_sig,  "global");
endmodule

// `endif
