//******************************************************************************
//
// Copyright 2026 IHP PDK Authors
//
// Licensed under the Apache License, Version 2.0 (the "License");
// you may not use this file except in compliance with the License.
// You may obtain a copy of the License at
//
//    https://www.apache.org/licenses/LICENSE-2.0
//
// Unless required by applicable law or agreed to in writing, software
// distributed under the License is distributed on an "AS IS" BASIS,
// WITHOUT WARRANTIES OR CONDITIONS OF ANY KIND, either express or implied.
// See the License for the specific language governing permissions and
// limitations under the License.
//
//******************************************************************************
//******************************************************************************
//
//
//                            M O S     C O R N E R S
//
//
//******************************************************************************
//
// Corner naming scheme: typical mean=tt, worst case=ss, best case=ff, combinations sf, fs, ...
// Digit Devices

//******************************************************************************
// MOSHV corner modules
//
// Adapted from `ngspice/models/cornerMOShv.lib`
//
// Modifications:
// - Removed mismatch corners; mismatch is implemented in paramsets
// - Moved global process-variation parameters into the statistical corner
//******************************************************************************

// TODO: Enable include guards once Gnucap runtime Verilog loading supports preprocessing.
// `ifndef SG13G2_CORNER_MOSHV_VA
// `define SG13G2_CORNER_MOSHV_VA

(* desc = "Typical High-Voltage SG13G2 MOS corner (tt: typical n, typical p)" *)
module moshv_tt();
    // nmos
    localparam real sg13g2_hv_nmos_vfbo = 1.0;
    localparam real sg13g2_hv_nmos_rsgo = 1.0000;
    localparam real sg13g2_hv_nmos_rsw1 = 0.7886;
    localparam real sg13g2_hv_nmos_mueo = 1.0780;
    localparam real sg13g2_hv_nmos_dphibo = 1.4388;
    localparam real sg13g2_hv_nmos_dphibl = 1.5299;
    localparam real sg13g2_hv_nmos_dphibw = 1.0000;
    localparam real sg13g2_hv_nmos_dphiblw = 0.8712;
    localparam real sg13g2_hv_nmos_ctl = 1.0000;
    localparam real sg13g2_hv_nmos_thesato = 1.0000;
    localparam real sg13g2_hv_nmos_thesatl = 1.0350;
    localparam real sg13g2_hv_nmos_thesatw = 1.0000;
    localparam real sg13g2_hv_nmos_thesatlw = 1.6050;
    localparam real sg13g2_hv_nmos_toxo = 1.0000;
    localparam real sg13g2_hv_nmos_toxovo = 1.0000;
    localparam real sg13g2_hv_nmos_cjorbot = 1.0000;
    localparam real sg13g2_hv_nmos_cjorsti = 1.0000;
    localparam real sg13g2_hv_nmos_cjorgat = 1.0000;
    // pmos
    localparam real sg13g2_hv_pmos_vfbo = 1.0;
    localparam real sg13g2_hv_pmos_rsgo = 1.1110;
    localparam real sg13g2_hv_pmos_rsw1 = 1.0000;
    localparam real sg13g2_hv_pmos_mueo = 0.9605;
    localparam real sg13g2_hv_pmos_dphibo = 1.0010;
    localparam real sg13g2_hv_pmos_dphibl = 0.9504;
    localparam real sg13g2_hv_pmos_dphibw = 1.4080;
    localparam real sg13g2_hv_pmos_dphiblw = -0.1693;
    localparam real sg13g2_hv_pmos_bgidlo = 0.8409;
    localparam real sg13g2_hv_pmos_thesato = 1.0000;
    localparam real sg13g2_hv_pmos_thesatl = 0.4814;
    localparam real sg13g2_hv_pmos_thesatw = 5.7745;
    localparam real sg13g2_hv_pmos_thesatlw = 1.0000;
    localparam real sg13g2_hv_pmos_csl = 1.0000;
    localparam real sg13g2_hv_pmos_toxo = 1.0000;
    localparam real sg13g2_hv_pmos_toxovo = 1.0000;
    localparam real sg13g2_hv_pmos_cjorbot = 1.0000;
    localparam real sg13g2_hv_pmos_cjorsti = 1.0000;
    localparam real sg13g2_hv_pmos_cjorgat = 1.0000;
    // svaricaphv
    localparam real sg13g2_hv_svaricap_vfbo = 1.0;
    localparam real sg13g2_hv_svaricap_toxo = 1.0;
    localparam real sg13g2_hv_svaricap_dlq = 1.0;
    localparam real sg13g2_hv_svaricap_dwq = 1.0;
endmodule

(* desc = "Worst-case High-Voltage SG13G2 MOS corner (ss: slow n, slow p)" *)
module moshv_ss();
    // nmos
    localparam real sg13g2_hv_nmos_vfbo = 1.0;
    localparam real sg13g2_hv_nmos_rsgo = 1.0000;
    localparam real sg13g2_hv_nmos_rsw1 = 0.7880;
    localparam real sg13g2_hv_nmos_mueo = 1.1670;
    localparam real sg13g2_hv_nmos_dphibo = 1.0117;
    localparam real sg13g2_hv_nmos_dphibl = 0.9004;
    localparam real sg13g2_hv_nmos_dphibw = 1.0000;
    localparam real sg13g2_hv_nmos_dphiblw = 0.8247;
    localparam real sg13g2_hv_nmos_ctl = 1.0000;
    localparam real sg13g2_hv_nmos_thesato = 1.0000;
    localparam real sg13g2_hv_nmos_thesatl = 1.1610;
    localparam real sg13g2_hv_nmos_thesatw = 1.0000;
    localparam real sg13g2_hv_nmos_thesatlw = 1.4830;
    localparam real sg13g2_hv_nmos_toxo = 1.0400;
    localparam real sg13g2_hv_nmos_toxovo = 1.0400;
    localparam real sg13g2_hv_nmos_cjorbot = 1.0800;
    localparam real sg13g2_hv_nmos_cjorsti = 1.0800;
    localparam real sg13g2_hv_nmos_cjorgat = 1.0800;
    // pmos
    localparam real sg13g2_hv_pmos_vfbo = 1.0;
    localparam real sg13g2_hv_pmos_rsgo = -0.0510;
    localparam real sg13g2_hv_pmos_rsw1 = 1.0000;
    localparam real sg13g2_hv_pmos_mueo = 0.9619;
    localparam real sg13g2_hv_pmos_dphibo = 0.8319;
    localparam real sg13g2_hv_pmos_dphibl = 1.1490;
    localparam real sg13g2_hv_pmos_dphibw = 1.4480;
    localparam real sg13g2_hv_pmos_dphiblw = 2.7230;
    localparam real sg13g2_hv_pmos_bgidlo = 1.4000;
    localparam real sg13g2_hv_pmos_thesato = 1.0000;
    localparam real sg13g2_hv_pmos_thesatl = 0.6000;
    localparam real sg13g2_hv_pmos_thesatw = 3.7378;
    localparam real sg13g2_hv_pmos_thesatlw = 1.0000;
    localparam real sg13g2_hv_pmos_csl = 1.0000;
    localparam real sg13g2_hv_pmos_toxo = 1.0400;
    localparam real sg13g2_hv_pmos_toxovo = 1.0400;
    localparam real sg13g2_hv_pmos_cjorbot = 1.0800;
    localparam real sg13g2_hv_pmos_cjorsti = 1.0800;
    localparam real sg13g2_hv_pmos_cjorgat = 1.0800;
    // svaricaphv
    localparam real sg13g2_hv_svaricap_vfbo = 0.8;
    localparam real sg13g2_hv_svaricap_toxo = 1.04;
    localparam real sg13g2_hv_svaricap_dlq = 1.05;
    localparam real sg13g2_hv_svaricap_dwq = 1.05;
endmodule

(* desc = "Best-case High-Voltage SG13G2 MOS corner (ff: fast n, fast p)" *)
module moshv_ff();
    // nmos
    localparam real sg13g2_hv_nmos_vfbo = 1.0;
    localparam real sg13g2_hv_nmos_rsgo = 1.0000;
    localparam real sg13g2_hv_nmos_rsw1 = 0.7880;
    localparam real sg13g2_hv_nmos_mueo = 0.9662;
    localparam real sg13g2_hv_nmos_dphibo = 1.9136;
    localparam real sg13g2_hv_nmos_dphibl = 2.1315;
    localparam real sg13g2_hv_nmos_dphibw = 1.0000;
    localparam real sg13g2_hv_nmos_dphiblw = 0.9151;
    localparam real sg13g2_hv_nmos_ctl = 1.0000;
    localparam real sg13g2_hv_nmos_thesato = 1.0000;
    localparam real sg13g2_hv_nmos_thesatl = 0.9463;
    localparam real sg13g2_hv_nmos_thesatw = 1.0000;
    localparam real sg13g2_hv_nmos_thesatlw = 1.6950;
    localparam real sg13g2_hv_nmos_toxo = 0.9600;
    localparam real sg13g2_hv_nmos_toxovo = 0.9600;
    localparam real sg13g2_hv_nmos_cjorbot = 0.9200;
    localparam real sg13g2_hv_nmos_cjorsti = 0.9200;
    localparam real sg13g2_hv_nmos_cjorgat = 0.9200;
    // pmos
    localparam real sg13g2_hv_pmos_vfbo = 1.0;
    localparam real sg13g2_hv_pmos_rsgo = 2.5010;
    localparam real sg13g2_hv_pmos_rsw1 = 1.0000;
    localparam real sg13g2_hv_pmos_mueo = 0.9687;
    localparam real sg13g2_hv_pmos_dphibo = 1.1750;
    localparam real sg13g2_hv_pmos_dphibl = 0.7456;
    localparam real sg13g2_hv_pmos_dphibw = 1.3380;
    localparam real sg13g2_hv_pmos_dphiblw = -3.3600;
    localparam real sg13g2_hv_pmos_bgidlo = 0.4770;
    localparam real sg13g2_hv_pmos_thesato = 1.0000;
    localparam real sg13g2_hv_pmos_thesatl = 0.5000;
    localparam real sg13g2_hv_pmos_thesatw = 6.3581;
    localparam real sg13g2_hv_pmos_thesatlw = 1.0000;
    localparam real sg13g2_hv_pmos_csl = 1.0000;
    localparam real sg13g2_hv_pmos_toxo = 0.9600;
    localparam real sg13g2_hv_pmos_toxovo = 0.9600;
    localparam real sg13g2_hv_pmos_cjorbot = 0.9200;
    localparam real sg13g2_hv_pmos_cjorsti = 0.9200;
    localparam real sg13g2_hv_pmos_cjorgat = 0.9200;
    // svaricaphv
    localparam real sg13g2_hv_svaricap_vfbo = 1.2;
    localparam real sg13g2_hv_svaricap_toxo = 0.96;
    localparam real sg13g2_hv_svaricap_dlq = 0.90;
    localparam real sg13g2_hv_svaricap_dwq = 0.90;
endmodule

(* desc = "Slow/Fast High-Voltage SG13G2 MOS corner (sf: slow n, fast p)" *)
module moshv_sf();
    // nmos
    localparam real sg13g2_hv_nmos_vfbo = 1.0;
    localparam real sg13g2_hv_nmos_rsgo = 1.0000;
    localparam real sg13g2_hv_nmos_rsw1 = 0.7883;
    localparam real sg13g2_hv_nmos_mueo = 1.1225;
    localparam real sg13g2_hv_nmos_dphibo = 1.2252;
    localparam real sg13g2_hv_nmos_dphibl = 1.2151;
    localparam real sg13g2_hv_nmos_dphibw = 1.0000;
    localparam real sg13g2_hv_nmos_dphiblw = 0.8479;
    localparam real sg13g2_hv_nmos_ctl = 1.0000;
    localparam real sg13g2_hv_nmos_thesato = 1.0000;
    localparam real sg13g2_hv_nmos_thesatl = 1.0980;
    localparam real sg13g2_hv_nmos_thesatw = 1.0000;
    localparam real sg13g2_hv_nmos_thesatlw = 1.5440;
    localparam real sg13g2_hv_nmos_toxo = 1.0200;
    localparam real sg13g2_hv_nmos_toxovo = 1.0200;
    localparam real sg13g2_hv_nmos_cjorbot = 1.0400;
    localparam real sg13g2_hv_nmos_cjorsti = 1.0400;
    localparam real sg13g2_hv_nmos_cjorgat = 1.0400;
    // pmos
    localparam real sg13g2_hv_pmos_vfbo = 1.0;
    localparam real sg13g2_hv_pmos_rsgo = 1.8060;
    localparam real sg13g2_hv_pmos_rsw1 = 1.0000;
    localparam real sg13g2_hv_pmos_mueo = 0.9646;
    localparam real sg13g2_hv_pmos_dphibo = 1.0880;
    localparam real sg13g2_hv_pmos_dphibl = 0.8480;
    localparam real sg13g2_hv_pmos_dphibw = 1.3730;
    localparam real sg13g2_hv_pmos_dphiblw = -1.7647;
    localparam real sg13g2_hv_pmos_bgidlo = 0.6589;
    localparam real sg13g2_hv_pmos_thesato = 1.0000;
    localparam real sg13g2_hv_pmos_thesatl = 0.4907;
    localparam real sg13g2_hv_pmos_thesatw = 6.0663;
    localparam real sg13g2_hv_pmos_thesatlw = 1.0000;
    localparam real sg13g2_hv_pmos_csl = 1.0000;
    localparam real sg13g2_hv_pmos_toxo = 0.9800;
    localparam real sg13g2_hv_pmos_toxovo = 0.9800;
    localparam real sg13g2_hv_pmos_cjorbot = 0.9600;
    localparam real sg13g2_hv_pmos_cjorsti = 0.9600;
    localparam real sg13g2_hv_pmos_cjorgat = 0.9600;
    // svaricaphv
    localparam real sg13g2_hv_svaricap_vfbo = 0.8;
    localparam real sg13g2_hv_svaricap_toxo = 1.02;
    localparam real sg13g2_hv_svaricap_dlq = 1.1;
    localparam real sg13g2_hv_svaricap_dwq = 1.1;
endmodule

(* desc = "Fast/Slow High-Voltage SG13G2 MOS corner (fs: fast n, slow p)" *)
module moshv_fs();
    // nmos
    localparam real sg13g2_hv_nmos_vfbo = 1.0;
    localparam real sg13g2_hv_nmos_rsgo = 1.0000;
    localparam real sg13g2_hv_nmos_rsw1 = 0.7883;
    localparam real sg13g2_hv_nmos_mueo = 1.0221;
    localparam real sg13g2_hv_nmos_dphibo = 1.6762;
    localparam real sg13g2_hv_nmos_dphibl = 1.8307;
    localparam real sg13g2_hv_nmos_dphibw = 1.0000;
    localparam real sg13g2_hv_nmos_dphiblw = 0.8932;
    localparam real sg13g2_hv_nmos_ctl = 1.0000;
    localparam real sg13g2_hv_nmos_thesato = 1.0000;
    localparam real sg13g2_hv_nmos_thesatl = 0.9907;
    localparam real sg13g2_hv_nmos_thesatw = 1.0000;
    localparam real sg13g2_hv_nmos_thesatlw = 1.6500;
    localparam real sg13g2_hv_nmos_toxo = 0.9800;
    localparam real sg13g2_hv_nmos_toxovo = 0.9800;
    localparam real sg13g2_hv_nmos_cjorbot = 0.9600;
    localparam real sg13g2_hv_nmos_cjorsti = 0.9600;
    localparam real sg13g2_hv_nmos_cjorgat = 0.9600;
    // pmos
    localparam real sg13g2_hv_pmos_vfbo = 1.0;
    localparam real sg13g2_hv_pmos_rsgo = 0.5300;
    localparam real sg13g2_hv_pmos_rsw1 = 1.0000;
    localparam real sg13g2_hv_pmos_mueo = 0.9612;
    localparam real sg13g2_hv_pmos_dphibo = 0.9164;
    localparam real sg13g2_hv_pmos_dphibl = 1.0497;
    localparam real sg13g2_hv_pmos_dphibw = 1.4280;
    localparam real sg13g2_hv_pmos_dphiblw = 1.2769;
    localparam real sg13g2_hv_pmos_bgidlo = 1.1204;
    localparam real sg13g2_hv_pmos_thesato = 1.0000;
    localparam real sg13g2_hv_pmos_thesatl = 0.5407;
    localparam real sg13g2_hv_pmos_thesatw = 4.7562;
    localparam real sg13g2_hv_pmos_thesatlw = 1.0000;
    localparam real sg13g2_hv_pmos_csl = 1.0000;
    localparam real sg13g2_hv_pmos_toxo = 1.0200;
    localparam real sg13g2_hv_pmos_toxovo = 1.0200;
    localparam real sg13g2_hv_pmos_cjorbot = 1.0400;
    localparam real sg13g2_hv_pmos_cjorsti = 1.0400;
    localparam real sg13g2_hv_pmos_cjorgat = 1.0400;
    // svaricaphv
    localparam real sg13g2_hv_svaricap_vfbo = 1.2;
    localparam real sg13g2_hv_svaricap_toxo = 0.98;
    localparam real sg13g2_hv_svaricap_dlq = 0.90;
    localparam real sg13g2_hv_svaricap_dwq = 0.90;
endmodule
(* desc = "Typical statistical High-Voltage SG13G2 MOS corner (tt: typical n, typical p)" *)
module moshv_tt_stat();
    parameter integer seed = 0;
    // nmos nominal
    localparam real sg13g2_hv_nmos_vfbo_nom     = 1.0;
    localparam real sg13g2_hv_nmos_rsgo_nom     = 1.0000;
    localparam real sg13g2_hv_nmos_rsw1_nom     = 0.7886;
    localparam real sg13g2_hv_nmos_mueo_nom     = 1.0780;
    localparam real sg13g2_hv_nmos_dphibo_nom   = 1.4388;
    localparam real sg13g2_hv_nmos_dphibl_nom   = 1.5299;
    localparam real sg13g2_hv_nmos_dphibw_nom   = 1.0000;
    localparam real sg13g2_hv_nmos_dphiblw_nom  = 0.8712;
    localparam real sg13g2_hv_nmos_ctl_nom      = 1.0000;
    localparam real sg13g2_hv_nmos_thesato_nom  = 1.0000;
    localparam real sg13g2_hv_nmos_thesatl_nom  = 1.0350;
    localparam real sg13g2_hv_nmos_thesatw_nom  = 1.0000;
    localparam real sg13g2_hv_nmos_thesatlw_nom = 1.6050;
    localparam real sg13g2_hv_nmos_toxo_nom     = 1.0000;
    localparam real sg13g2_hv_nmos_toxovo_nom   = 1.0000;
    localparam real sg13g2_hv_nmos_cjorbot_nom  = 1.0000;
    localparam real sg13g2_hv_nmos_cjorsti_nom  = 1.0000;
    localparam real sg13g2_hv_nmos_cjorgat_nom  = 1.0000;
    // nmos sigma
    localparam real sg13g2_hv_nmos_vfbo_sig     = 0.004  * sg13g2_hv_nmos_vfbo_nom;
    localparam real sg13g2_hv_nmos_rsgo_sig     = 1e-9   * sg13g2_hv_nmos_rsgo_nom;
    localparam real sg13g2_hv_nmos_rsw1_sig     = 0.0001 * sg13g2_hv_nmos_rsw1_nom;
    localparam real sg13g2_hv_nmos_mueo_sig     = 0.0335 * sg13g2_hv_nmos_mueo_nom;
    localparam real sg13g2_hv_nmos_dphibo_sig   = 0.1503 * sg13g2_hv_nmos_dphibo_nom;
    localparam real sg13g2_hv_nmos_dphibl_sig   = 0.2052 * sg13g2_hv_nmos_dphibl_nom;
    localparam real sg13g2_hv_nmos_dphibw_sig   = 1e-9   * sg13g2_hv_nmos_dphibw_nom;
    localparam real sg13g2_hv_nmos_dphiblw_sig  = 0.0151 * sg13g2_hv_nmos_dphiblw_nom;
    localparam real sg13g2_hv_nmos_ctl_sig      = 1e-9   * sg13g2_hv_nmos_ctl_nom;
    localparam real sg13g2_hv_nmos_thesato_sig  = 1e-9   * sg13g2_hv_nmos_thesato_nom;
    localparam real sg13g2_hv_nmos_thesatl_sig  = 0.0358 * sg13g2_hv_nmos_thesatl_nom;
    localparam real sg13g2_hv_nmos_thesatw_sig  = 1e-9   * sg13g2_hv_nmos_thesatw_nom;
    localparam real sg13g2_hv_nmos_thesatlw_sig = 0.0353 * sg13g2_hv_nmos_thesatlw_nom;
    localparam real sg13g2_hv_nmos_toxo_sig     = 0.0133 * sg13g2_hv_nmos_toxo_nom;
    localparam real sg13g2_hv_nmos_toxovo_sig   = 0.0133 * sg13g2_hv_nmos_toxovo_nom;
    localparam real sg13g2_hv_nmos_cjorbot_sig  = 0.0267 * sg13g2_hv_nmos_cjorbot_nom;
    localparam real sg13g2_hv_nmos_cjorsti_sig  = 0.0267 * sg13g2_hv_nmos_cjorsti_nom;
    localparam real sg13g2_hv_nmos_cjorgat_sig  = 0.0267 * sg13g2_hv_nmos_cjorgat_nom;
    // nmos params with global process variation
    localparam real sg13g2_hv_nmos_vfbo     = $rdist_normal(seed + 1, sg13g2_hv_nmos_vfbo_nom,      sg13g2_hv_nmos_vfbo_sig,     "global");
    localparam real sg13g2_hv_nmos_rsgo     = $rdist_normal(seed + 2, sg13g2_hv_nmos_rsgo_nom,      sg13g2_hv_nmos_rsgo_sig,     "global");
    localparam real sg13g2_hv_nmos_rsw1     = $rdist_normal(seed + 3, sg13g2_hv_nmos_rsw1_nom,      sg13g2_hv_nmos_rsw1_sig,     "global");
    localparam real sg13g2_hv_nmos_mueo     = $rdist_normal(seed + 4, sg13g2_hv_nmos_mueo_nom,      sg13g2_hv_nmos_mueo_sig,     "global");
    localparam real sg13g2_hv_nmos_dphibo   = $rdist_normal(seed + 5, sg13g2_hv_nmos_dphibo_nom,    sg13g2_hv_nmos_dphibo_sig,   "global");
    localparam real sg13g2_hv_nmos_dphibl   = $rdist_normal(seed + 6, sg13g2_hv_nmos_dphibl_nom,    sg13g2_hv_nmos_dphibl_sig,   "global");
    localparam real sg13g2_hv_nmos_dphibw   = $rdist_normal(seed + 7, sg13g2_hv_nmos_dphibw_nom,    sg13g2_hv_nmos_dphibw_sig,   "global");
    localparam real sg13g2_hv_nmos_dphiblw  = $rdist_normal(seed + 8, sg13g2_hv_nmos_dphiblw_nom,   sg13g2_hv_nmos_dphiblw_sig,  "global");
    localparam real sg13g2_hv_nmos_ctl      = $rdist_normal(seed + 9, sg13g2_hv_nmos_ctl_nom,       sg13g2_hv_nmos_ctl_sig,      "global");
    localparam real sg13g2_hv_nmos_thesato  = $rdist_normal(seed + 10, sg13g2_hv_nmos_thesato_nom,  sg13g2_hv_nmos_thesato_sig,  "global");
    localparam real sg13g2_hv_nmos_thesatl  = $rdist_normal(seed + 11, sg13g2_hv_nmos_thesatl_nom,  sg13g2_hv_nmos_thesatl_sig,  "global");
    localparam real sg13g2_hv_nmos_thesatw  = $rdist_normal(seed + 12, sg13g2_hv_nmos_thesatw_nom,  sg13g2_hv_nmos_thesatw_sig,  "global");
    localparam real sg13g2_hv_nmos_thesatlw = $rdist_normal(seed + 13, sg13g2_hv_nmos_thesatlw_nom, sg13g2_hv_nmos_thesatlw_sig, "global");
    localparam real sg13g2_hv_nmos_toxo     = $rdist_normal(seed + 14, sg13g2_hv_nmos_toxo_nom,     sg13g2_hv_nmos_toxo_sig,     "global");
    localparam real sg13g2_hv_nmos_toxovo   = $rdist_normal(seed + 15, sg13g2_hv_nmos_toxovo_nom,   sg13g2_hv_nmos_toxovo_sig,   "global");
    localparam real sg13g2_hv_nmos_cjorbot  = $rdist_normal(seed + 16, sg13g2_hv_nmos_cjorbot_nom,  sg13g2_hv_nmos_cjorbot_sig,  "global");
    localparam real sg13g2_hv_nmos_cjorsti  = $rdist_normal(seed + 17, sg13g2_hv_nmos_cjorsti_nom,  sg13g2_hv_nmos_cjorsti_sig,  "global");
    localparam real sg13g2_hv_nmos_cjorgat  = $rdist_normal(seed + 18, sg13g2_hv_nmos_cjorgat_nom,  sg13g2_hv_nmos_cjorgat_sig,  "global");
    // pmos nominal
    localparam real sg13g2_hv_pmos_vfbo_nom     = 1.0;
    localparam real sg13g2_hv_pmos_rsgo_nom     = 1.1110;
    localparam real sg13g2_hv_pmos_rsw1_nom     = 1.0000;
    localparam real sg13g2_hv_pmos_mueo_nom     = 0.9605;
    localparam real sg13g2_hv_pmos_dphibo_nom   = 1.0010;
    localparam real sg13g2_hv_pmos_dphibl_nom   = 0.9504;
    localparam real sg13g2_hv_pmos_dphibw_nom   = 1.4080;
    localparam real sg13g2_hv_pmos_dphiblw_nom  = -0.1693;
    localparam real sg13g2_hv_pmos_bgidlo_nom   = 0.8409;
    localparam real sg13g2_hv_pmos_thesato_nom  = 1.0000;
    localparam real sg13g2_hv_pmos_thesatl_nom  = 0.4814;
    localparam real sg13g2_hv_pmos_thesatw_nom  = 5.7745;
    localparam real sg13g2_hv_pmos_thesatlw_nom = 1.0000;
    localparam real sg13g2_hv_pmos_csl_nom      = 1.0000;
    localparam real sg13g2_hv_pmos_toxo_nom     = 1.0000;
    localparam real sg13g2_hv_pmos_toxovo_nom   = 1.0000;
    localparam real sg13g2_hv_pmos_cjorbot_nom  = 1.0000;
    localparam real sg13g2_hv_pmos_cjorsti_nom  = 1.0000;
    localparam real sg13g2_hv_pmos_cjorgat_nom  = 1.0000;
    // pmos sigma
    localparam real sg13g2_hv_pmos_vfbo_sig     = 0.004  * sg13g2_hv_pmos_vfbo_nom;
    localparam real sg13g2_hv_pmos_rsgo_sig     = 0.4253 * sg13g2_hv_pmos_rsgo_nom;
    localparam real sg13g2_hv_pmos_rsw1_sig     = 1e-9   * sg13g2_hv_pmos_rsw1_nom;
    localparam real sg13g2_hv_pmos_mueo_sig     = 0.0014 * sg13g2_hv_pmos_mueo_nom;
    localparam real sg13g2_hv_pmos_dphibo_sig   = 0.0572 * sg13g2_hv_pmos_dphibo_nom;
    localparam real sg13g2_hv_pmos_dphibl_sig   = 0.0672 * sg13g2_hv_pmos_dphibl_nom;
    localparam real sg13g2_hv_pmos_dphibw_sig   = 0.0183 * sg13g2_hv_pmos_dphibw_nom;
    localparam real sg13g2_hv_pmos_dphiblw_sig  = 1.0138 * sg13g2_hv_pmos_dphiblw_nom;
    localparam real sg13g2_hv_pmos_bgidlo_sig   = 0.1538 * sg13g2_hv_pmos_bgidlo_nom;
    localparam real sg13g2_hv_pmos_thesato_sig  = 1e-9   * sg13g2_hv_pmos_thesato_nom;
    localparam real sg13g2_hv_pmos_thesatl_sig  = 0.0198 * sg13g2_hv_pmos_thesatl_nom;
    localparam real sg13g2_hv_pmos_thesatw_sig  = 0.4367 * sg13g2_hv_pmos_thesatw_nom;
    localparam real sg13g2_hv_pmos_thesatlw_sig = 1e-9   * sg13g2_hv_pmos_thesatlw_nom;
    localparam real sg13g2_hv_pmos_csl_sig      = 1e-9   * sg13g2_hv_pmos_csl_nom;
    localparam real sg13g2_hv_pmos_toxo_sig     = 0.0133 * sg13g2_hv_pmos_toxo_nom;
    localparam real sg13g2_hv_pmos_toxovo_sig   = 0.0133 * sg13g2_hv_pmos_toxovo_nom;
    localparam real sg13g2_hv_pmos_cjorbot_sig  = 0.0267 * sg13g2_hv_pmos_cjorbot_nom;
    localparam real sg13g2_hv_pmos_cjorsti_sig  = 0.0267 * sg13g2_hv_pmos_cjorsti_nom;
    localparam real sg13g2_hv_pmos_cjorgat_sig  = 0.0267 * sg13g2_hv_pmos_cjorgat_nom;
    // pmos params with global process variation
    localparam real sg13g2_hv_pmos_vfbo     = $rdist_normal(seed + 19, sg13g2_hv_pmos_vfbo_nom,     sg13g2_hv_pmos_vfbo_sig,     "global");
    localparam real sg13g2_hv_pmos_rsgo     = $rdist_normal(seed + 20, sg13g2_hv_pmos_rsgo_nom,     sg13g2_hv_pmos_rsgo_sig,     "global");
    localparam real sg13g2_hv_pmos_rsw1     = $rdist_normal(seed + 21, sg13g2_hv_pmos_rsw1_nom,     sg13g2_hv_pmos_rsw1_sig,     "global");
    localparam real sg13g2_hv_pmos_mueo     = $rdist_normal(seed + 22, sg13g2_hv_pmos_mueo_nom,     sg13g2_hv_pmos_mueo_sig,     "global");
    localparam real sg13g2_hv_pmos_dphibo   = $rdist_normal(seed + 23, sg13g2_hv_pmos_dphibo_nom,   sg13g2_hv_pmos_dphibo_sig,   "global");
    localparam real sg13g2_hv_pmos_dphibl   = $rdist_normal(seed + 24, sg13g2_hv_pmos_dphibl_nom,   sg13g2_hv_pmos_dphibl_sig,   "global");
    localparam real sg13g2_hv_pmos_dphibw   = $rdist_normal(seed + 25, sg13g2_hv_pmos_dphibw_nom,   sg13g2_hv_pmos_dphibw_sig,   "global");
    localparam real sg13g2_hv_pmos_dphiblw  = $rdist_normal(seed + 26, sg13g2_hv_pmos_dphiblw_nom,  sg13g2_hv_pmos_dphiblw_sig,  "global");
    localparam real sg13g2_hv_pmos_bgidlo   = $rdist_normal(seed + 27, sg13g2_hv_pmos_bgidlo_nom,   sg13g2_hv_pmos_bgidlo_sig,   "global");
    localparam real sg13g2_hv_pmos_thesato  = $rdist_normal(seed + 28, sg13g2_hv_pmos_thesato_nom,  sg13g2_hv_pmos_thesato_sig,  "global");
    localparam real sg13g2_hv_pmos_thesatl  = $rdist_normal(seed + 29, sg13g2_hv_pmos_thesatl_nom,  sg13g2_hv_pmos_thesatl_sig,  "global");
    localparam real sg13g2_hv_pmos_thesatw  = $rdist_normal(seed + 30, sg13g2_hv_pmos_thesatw_nom,  sg13g2_hv_pmos_thesatw_sig,  "global");
    localparam real sg13g2_hv_pmos_thesatlw = $rdist_normal(seed + 31, sg13g2_hv_pmos_thesatlw_nom, sg13g2_hv_pmos_thesatlw_sig, "global");
    localparam real sg13g2_hv_pmos_csl      = $rdist_normal(seed + 32, sg13g2_hv_pmos_csl_nom,      sg13g2_hv_pmos_csl_sig,      "global");
    localparam real sg13g2_hv_pmos_toxo     = $rdist_normal(seed + 33, sg13g2_hv_pmos_toxo_nom,     sg13g2_hv_pmos_toxo_sig,     "global");
    localparam real sg13g2_hv_pmos_toxovo   = $rdist_normal(seed + 34, sg13g2_hv_pmos_toxovo_nom,   sg13g2_hv_pmos_toxovo_sig,   "global");
    localparam real sg13g2_hv_pmos_cjorbot  = $rdist_normal(seed + 35, sg13g2_hv_pmos_cjorbot_nom,  sg13g2_hv_pmos_cjorbot_sig,  "global");
    localparam real sg13g2_hv_pmos_cjorsti  = $rdist_normal(seed + 36, sg13g2_hv_pmos_cjorsti_nom,  sg13g2_hv_pmos_cjorsti_sig,  "global");
    localparam real sg13g2_hv_pmos_cjorgat  = $rdist_normal(seed + 37, sg13g2_hv_pmos_cjorgat_nom,  sg13g2_hv_pmos_cjorgat_sig,  "global");
    // svaricaphv
    localparam real sg13g2_hv_svaricap_vfbo_nom = 1.0;
    localparam real sg13g2_hv_svaricap_toxo_nom = 1.0;
    localparam real sg13g2_hv_svaricap_dlq_nom  = 1.0;
    localparam real sg13g2_hv_svaricap_dwq_nom  = 1.0;
    // svaricaphv sigma
    localparam real sg13g2_hv_svaricap_vfbo_sig = 0.04   * sg13g2_hv_svaricap_vfbo_nom;
    localparam real sg13g2_hv_svaricap_toxo_sig = 0.0133 * sg13g2_hv_svaricap_toxo_nom;
    localparam real sg13g2_hv_svaricap_dlq_sig  = 0.10   * sg13g2_hv_svaricap_dlq_nom;
    localparam real sg13g2_hv_svaricap_dwq_sig  = 0.10   * sg13g2_hv_svaricap_dwq_nom;
    // svaricaphv parameters with global process variation
    localparam real sg13g2_hv_svaricap_vfbo = $rdist_normal(seed + 38, sg13g2_hv_svaricap_vfbo_nom, sg13g2_hv_svaricap_vfbo_sig, "global");
    localparam real sg13g2_hv_svaricap_toxo = $rdist_normal(seed + 39, sg13g2_hv_svaricap_toxo_nom, sg13g2_hv_svaricap_toxo_sig, "global");
    localparam real sg13g2_hv_svaricap_dlq  = $rdist_normal(seed + 40, sg13g2_hv_svaricap_dlq_nom,  sg13g2_hv_svaricap_dlq_sig,  "global");
    localparam real sg13g2_hv_svaricap_dwq  = $rdist_normal(seed + 41, sg13g2_hv_svaricap_dwq_nom,  sg13g2_hv_svaricap_dwq_sig,  "global");
endmodule

// TODO: mm params are hard coded into paramsets, pull out of module instead?
(* desc = "High-Voltage SG13G2 MOS mismatch parameters" *)
module moshv_mm();
    // nmos
    localparam real sg13g2_hv_nmos_delvto_mm  = 0.007;
    localparam real sg13g2_hv_nmos_factuo_mm  = 0.005;
    localparam real sg13g2_hv_nmos_dw_mm      = 3e-9;
    localparam real sg13g2_hv_nmos_dl_mm      = 3e-9;
    // pmos
    localparam real sg13g2_hv_pmos_delvto_mm  = 0.0045;
    localparam real sg13g2_hv_pmos_factuo_mm  = 0.0040;
    localparam real sg13g2_hv_pmos_dw_mm      = 3e-9;
    localparam real sg13g2_hv_pmos_dl_mm      = 3e-9;
endmodule

// `endif
