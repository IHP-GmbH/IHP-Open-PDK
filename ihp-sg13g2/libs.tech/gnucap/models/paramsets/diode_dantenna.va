//******************************************************************************
//
// Copyright 2026 IHP PDK Authors
//
// Licensed under the Apache License, Version 2.0 (the "License");
// you may not use this file except in compliance with the License.
// You may obtain a copy of the License at
//
//     https://www.apache.org/licenses/LICENSE-2.0
//
// Unless required by applicable law or agreed to in writing, software
// distributed under the License is distributed on an "AS IS" BASIS,
// WITHOUT WARRANTIES OR CONDITIONS OF ANY KIND, either express or implied.
// See the License for the specific language governing permissions and
// limitations under the License.
//
//******************************************************************************

//******************************************************************************
// dantenna diode paramsets
//
// Adapted from model declarations in ngspice/models/diode.lib
//******************************************************************************

(* desc = "dantenna diode paramset: area-contribution" *)
paramset darea sp_diode
    (* desc = "Area scale factor" *)
    parameter real area = 1 from (0:inf);

    .area = area;
    .tnom = 27;
    .is   = 2.315E-19;
    .n    = 1.009;
    .ikf  = 1.434E-7;
    .rs   = 2.193E+5;
    .cjo  = 9.371E-16;
    .m    = 0.3036;
    .vj   = 0.696;
    .fc   = 0.5;
    .bv   = 11.64;
    .ibv  = 3.458E-7;
    .tcv  = 0.001;
    .nbv  = 48.9;
    .isr  = 7.413E-19;
    .xti  = 5.039;
    .trs  = 0;
    .trs2 = 0;
    .tt   = 7.009E-7;
endparamset

(* desc = "dantenna diode paramset: perimeter-contribution" *)
paramset dperim sp_diode
    (* desc = "Area scale factor" *)
    parameter real area = 1 from (0:inf);

    .area = area;
    .tnom = 27;
    .is   = 3.851E-21;
    .n    = 1.022;
    .ikf  = 7.838E-8;
    .rs   = 1.688E+6;
    .isr  = 1.011E-17;
    .xti  = 3;
    .bv   = 31.86;
    .ibv  = 6.115E-14;
    .nbv  = 112.1;
    .cjo  = 1.821E-17;
    .m    = 0.01923;
    .vj   = 0.598;
    .tt   = 7.009E-7;
endparamset

(* desc = "dantenna diode paramset: corner-contribution" *)
paramset dcorner sp_diode
    (* desc = "Area scale factor" *)
    parameter real area = 1 from (0:inf);

    .area = area;
    .tnom = 27;
    .is   = 6.502E-21;
    .n    = 1;
    .ikf  = 1E-6;
    .rs   = 4.857E+5;
    .isr  = 0;
    .xti  = 3;
    .bv   = 11.64;
    .ibv  = 3.458E-7;
    .cjo  = 0;
    .m    = 0.5;
    .vj   = 0.7;
endparamset
