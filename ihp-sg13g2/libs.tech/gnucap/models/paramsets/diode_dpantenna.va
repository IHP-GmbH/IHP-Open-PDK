//******************************************************************************
//
// Copyright 2026 IHP PDK Authors
//
// Licensed under the Apache License, Version 2.0 (the "License");
// you may not use this file except in compliance with the License.
// You may obtain a copy of the License at
//
//     https://www.apache.org/licenses/LICENSE-2.0
//
// Unless required by applicable law or agreed to in writing, software
// distributed under the License is distributed on an "AS IS" BASIS,
// WITHOUT WARRANTIES OR CONDITIONS OF ANY KIND, either express or implied.
// See the License for the specific language governing permissions and
// limitations under the License.
//
//******************************************************************************

//******************************************************************************
// dpantenna diode paramsets
//
// Adapted from model declarations in ngspice/models/diode.lib
//******************************************************************************

(* desc = "dpantenna diode paramset: area-contribution" *)
paramset dparea sp_diode
    (* desc = "Area scale factor" *)
    parameter real area = 1 from (0:inf);

    .area = area;
    .tnom = 27;
    .is   = 8.569E-20;
    .n    = 1.003;
    .ikf  = 2.957E-7;
    .rs   = 1.728E+5;
    .cjo  = 8.252E-16;
    .m    = 0.3171;
    .vj   = 0.6628;
    .fc   = 0.5;
    .bv   = 12.14;
    .ibv  = 1E-6;
    .tcv  = 0.001;
    .nbv  = 11.85;
    .isr  = 2.421E-19;
    .xti  = 4.56;
    .trs  = 0;
    .trs2 = 0;
    .tt   = 1E-12;
endparamset

(* desc = "dpantenna diode paramset: perimeter-contribution" *)
paramset dpperim sp_diode
    (* desc = "Area scale factor" *)
    parameter real area = 1 from (0:inf);

    .area = area;
    .tnom = 27;
    .is   = 1.186E-20;
    .n    = 1.006;
    .ikf  = 2.158E-8;
    .rs   = 1.577E+6;
    .isr  = 7.211E-18;
    .xti  = 4.118;
    .bv   = 27.26;
    .ibv  = 1.832E-11;
    .nbv  = 32.47;
    .cjo  = 3.657E-17;
    .m    = 0.1512;
    .vj   = 0.5241;
    .tt   = 1E-12;
endparamset

(* desc = "dpcorner diode paramset: corner-contribution" *)
paramset dpcorner sp_diode
    (* desc = "Area scale factor" *)
    parameter real area = 1 from (0:inf);

    .area = area;
    .tnom = 27;
    .is   = 6.965E-21;
    .n    = 1;
    .ikf  = 1.19E-8;
    .rs   = 4.734E+5;
    .isr  = 0;
    .xti  = 3;
    .cjo  = 0;
    .m    = 0.5;
    .vj   = 0.7;
endparamset
