//******************************************************************************
//
// Copyright 2026 IHP PDK Authors
//
// Licensed under the Apache License, Version 2.0 (the "License");
// you may not use this file except in compliance with the License.
// You may obtain a copy of the License at
//
//     https://www.apache.org/licenses/LICENSE-2.0
//
// Unless required by applicable law or agreed to in writing, software
// distributed under the License is distributed on an "AS IS" BASIS,
// WITHOUT WARRANTIES OR CONDITIONS OF ANY KIND, either express or implied.
// See the License for the specific language governing permissions and
// limitations under the License.
//
//******************************************************************************

(* desc = "SVaricap well-to-substrate diode paramset" *)
paramset dsubw sp_diode
    (* desc = "Area scale factor" *)
    parameter real area = 1 from (0:inf);
    (* desc = "Perimeter scale factor" *)
    parameter real pj = 0 from [0:inf);

    .area = area;
    .pj = pj;
    .is = 2.45e-17;
    .jsw = 5.959e-10;
    .n = 4.0;
    .ns = 1.029;
    .cjo = 1.444e-15;
    .vj = 0.3357;
    .m = 0.1052;
    .cjp = 1.117e-9;
    .php = 0.457;
    .mjsw = 0.2595;
    .fc = 0.95;
    .cta = 1.0e-6;
endparamset
