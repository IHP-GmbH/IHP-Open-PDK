//******************************************************************************
//
// Copyright 2026 IHP PDK Authors
//
// Licensed under the Apache License, Version 2.0 (the "License");
// you may not use this file except in compliance with the License.
// You may obtain a copy of the License at
//
//    https://www.apache.org/licenses/LICENSE-2.0
//
// Unless required by applicable law or agreed to in writing, software
// distributed under the License is distributed on an "AS IS" BASIS,
// WITHOUT WARRANTIES OR CONDITIONS OF ANY KIND, either express or implied.
// See the License for the specific language governing permissions and
// limitations under the License.
//
//******************************************************************************

//******************************************************************************
// rhigh paramsets (with and without mismatch)
//
// Adapted from model declarations in ngspice/models/resistor_mod*.lib.
//******************************************************************************

(* desc = "rhigh resistor paramset without mismatch" *)
paramset rhigh r3_cmc
    (* desc = "Device width", units = "m" *)
    parameter real w = 0.5e-6 from [0.5e-6:10e-6);
    (* desc = "Device length", units = "m" *)
    parameter real l = 0.96e-6 from [0.96e-6:10e-6);
    (* desc = "Enable mismatch" *)
    parameter integer mm_ok = 0 from [0:0];
    (* desc = "Number of poly segments in series" *)
    parameter integer b = 0 from [0:inf);
    (* desc = "Local temperature offset from ambient (before self-heating)", units = "degC" *)
    parameter real trise = 0;
    (* desc = "Switch to include self-heating: 0=no and 1=yes" *)
    parameter integer sw_et = 0 from [0:1];
    (* desc = "Post-layout parasitic extraction flag" *)
    parameter integer postsim = 0 from [0:1];

    localparam real kappa = 1.85;
    localparam real ps = 0.18e-6;
    localparam real weff = w + corner_res.dw_par_rhigh;
    localparam real leff = (b + 1) * l + (2 / kappa * weff + ps) * b;
    localparam real lhead = 0.86e-6;
    localparam real rzspec = 80e-6;
    localparam real cax = 90e-18;
    localparam real cpx = 25e-18;
    localparam real ax = 175e-18 * (1 - 1 / (1.5 * leff * 1e6 + 1)) / cax;
    localparam real px = 115e-18 / cpx;
    localparam real a0 = 0.5 * (leff + lhead) * w - (postsim > 0) * w * ax * 1e-6;
    localparam real a = (a0 > 0) * a0;
    localparam real p0 = leff + lhead + w - (postsim > 0) * px * 1e-6;
    localparam real p = (p0 > 0) * p0;
    localparam real rshspec = 1360; // TODO: never used and not a r3_cmc param
    localparam real rqrc = 4.5e-6;
    localparam real rz = rzspec / w - (postsim > 0) * rqrc / w;

    .l = leff;
    .w = weff;
    .a1 = a;
    .a2 = a;
    .p1 = p;
    .p2 = p;
    .c1 = 1;
    .c2 = 1;
    .trise = trise;
    .sw_et = sw_et;
    .sw_mman = 0;
    .rsh = corner_res.rsh_rhigh;
    .ecrit = 1000;
    .dfinf = 1e-4;
    .dp = 1000;
    .xw = -0.04;
    .rc = rz;
    .ca = cax;
    .cp = cpx;
    .tc1 = -2300e-6;
    .tc2 = 2.1e-6;
    .tc1rc = -2300e-6;
    .tc2rc = 2.1e-6;
    .gth0 = 1e-12;
    .gtha = 6e-6;
    .gthp = 2e-6;
    .gthc = 1e-12;
    .cth0 = 0;
    .cthp = 0;
    .ctha = 594e-15;
    .cthc = 0;
    .kfn = 5.205e-10;
    .afn = 1.935;
    .bfn = 0.9086;
    .nsig_rsh = corner_res.nsig_rsh_rhigh;
    .nsig_w   = corner_res.nsig_w_rhigh;
    .nsig_l   = corner_res.nsig_l_rhigh;
    .sig_rsh  = res_stat_param.drsh_rhigh;
    .sig_w    = res_stat_param.dw_rhigh;
    .sig_l    = res_stat_param.dl_rhigh;
endparamset

(* desc = "rhigh resistor paramset with mismatch" *)
paramset rhigh r3_cmc
    (* desc = "Device width", units = "m" *)
    parameter real w = 0.5e-6 from [0.5e-6:10e-6);
    (* desc = "Device length", units = "m" *)
    parameter real l = 0.96e-6 from [0.96e-6:10e-6);
    (* desc = "Enable mismatch" *)
    parameter integer mm_ok = 1 from [1:1];
    (* desc = "Number of poly segments in series" *)
    parameter integer b = 0 from [0:inf);
    (* desc = "Local temperature offset from ambient (before self-heating)", units = "degC" *)
    parameter real trise = 0;
    (* desc = "Switch to include self-heating: 0=no and 1=yes" *)
    parameter integer sw_et = 0 from [0:1];
    (* desc = "Post-layout parasitic extraction flag" *)
    parameter integer postsim = 0 from [0:1];

    localparam real kappa = 1.85;
    localparam real ps = 0.18e-6;
    localparam real weff = w + corner_res.dw_par_rhigh;
    localparam real leff = (b + 1) * l + (2 / kappa * weff + ps) * b;
    localparam real lhead = 0.86e-6;
    localparam real rzspec = 80e-6;
    localparam real cax = 90e-18;
    localparam real cpx = 25e-18;
    localparam real ax = 175e-18 * (1 - 1 / (1.5 * leff * 1e6 + 1)) / cax;
    localparam real px = 115e-18 / cpx;
    localparam real a0 = 0.5 * (leff + lhead) * w - (postsim > 0) * w * ax * 1e-6;
    localparam real a = (a0 > 0) * a0;
    localparam real p0 = leff + lhead + w - (postsim > 0) * px * 1e-6;
    localparam real p = (p0 > 0) * p0;
    localparam real rshspec = 1360; // TODO: never used and not a r3_cmc param
    localparam real rqrc = 4.5e-6;
    localparam real rz = rzspec / w - (postsim > 0) * rqrc / w;

    .l = leff;
    .w = weff;
    .a1 = a;
    .a2 = a;
    .p1 = p;
    .p2 = p;
    .c1 = 1;
    .c2 = 1;
    .trise = trise;
    .sw_et = sw_et;
    .sw_mman = 1;
    .rsh = corner_res.rsh_rhigh;
    .ecrit = 1000;
    .dfinf = 1e-4;
    .dp = 1000;
    .xw = -0.04;
    .rc = rz;
    .ca = cax;
    .cp = cpx;
    .tc1 = -2300e-6;
    .tc2 = 2.1e-6;
    .tc1rc = -2300e-6;
    .tc2rc = 2.1e-6;
    .gth0 = 1e-12;
    .gtha = 6e-6;
    .gthp = 2e-6;
    .gthc = 1e-12;
    .cth0 = 0;
    .cthp = 0;
    .ctha = 594e-15;
    .cthc = 0;
    .kfn = 5.205e-10;
    .afn = 1.935;
    .bfn = 0.9086;
    .nsig_rsh = corner_res.nsig_rsh_rhigh;
    .nsig_w   = corner_res.nsig_w_rhigh;
    .nsig_l   = corner_res.nsig_l_rhigh;
    .sig_rsh  = res_stat_param.drsh_rhigh;
    .sig_w    = res_stat_param.dw_rhigh;
    .sig_l    = res_stat_param.dl_rhigh;
    .nsmm_rsh = res_mm.nsmm_rsh_rhigh;
    .nsmm_w   = res_mm.nsmm_w_rhigh;
    .nsmm_l   = res_mm.nsmm_l_rhigh;
    .smm_rsh  = res_mm.drsh_mm_rhigh;
    .smm_w    = res_mm.dw_mm_rhigh;
    .smm_l    = res_mm.dl_mm_rhigh;
endparamset
