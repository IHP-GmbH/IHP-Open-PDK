//******************************************************************************
//
// Copyright 2026 IHP PDK Authors
//
// Licensed under the Apache License, Version 2.0 (the "License");
// you may not use this file except in compliance with the License.
// You may obtain a copy of the License at
//
//     https://www.apache.org/licenses/LICENSE-2.0
//
// Unless required by applicable law or agreed to in writing, software
// distributed under the License is distributed on an "AS IS" BASIS,
// WITHOUT WARRANTIES OR CONDITIONS OF ANY KIND, either express or implied.
// See the License for the specific language governing permissions and
// limitations under the License.
//
//******************************************************************************

//******************************************************************************
// npn13G2 paramsets (with and without mismatch)
//
// Adapted from model declarations in ngspice/models/sg13g2_hbt_mod.lib.
//******************************************************************************

(* desc="npn13G2 vbic13_4t paramset, without mismatch" *)
paramset npn13G2_NX_vbic vbic13_4t
    (* desc = "Number of emitter fingers" *)
    parameter integer Nx = 1 from [1:10];
    (* desc = "Temperature offset w.r.t. ambient temperature" *)
    parameter real dtemp = 0.0;
    (* desc = "Enable self-heating" *)
    parameter real selft = 1.0;
    (* desc = "Enable non-quasi-static model" *)
    parameter integer sw_nqs = 0 from [0:1];
    (* desc = "Enable mismatch" *)
    parameter integer mm_ok = 0 from [0:0];

    localparam real Nx_scale = 0.25 * Nx;
    localparam real inv_Nx_scale = 1.0 / Nx_scale;

    .trise = dtemp;
    .tnom = 27;
    .cbeo = 8.00E-16 * pow(Nx_scale, 0.975);
    .cje = 8.418E-15 * pow(Nx_scale, 0.975) * corner_hbt.vbic_cje;
    .pe = 0.92;
    .me = 0.12;
    .aje = -0.50;
    .wbe = 1.00;
    .cbco = 2.36E-15 * Nx_scale;
    .cjc = 1.53E-15 * Nx_scale * corner_hbt.vbic_cjc;
    .pc = 0.558;
    .mc = 0.12;
    .ajc = -0.50;
    .cjep = 3.56E-15 * Nx_scale * corner_hbt.vbic_cjc;
    .cjcp = 4.56E-15 * pow(Nx_scale, 0.8) * corner_hbt.vbic_cjcp;
    .ps = 0.46;
    .ms = 0.23;
    .ajs = -0.50;
    .fc = 0.80;
    .vef = 189;
    .ver = 5.3;
    .is = 4.81E-17 * Nx_scale * corner_hbt.vbic_is;
    .nf = 1.018;
    .ibei = 1.9E-19 * Nx_scale * corner_hbt.vbic_ibei;
    .nei = 1.066;
    .iben = 4.00E-16 * Nx_scale;
    .nen = 2.00;
    .ikf = 0.009 * Nx_scale;
    .nr = 1.01;
    .ibci = 1.50E-20 * Nx_scale;
    .nci = 1.103;
    .ibcn = 1.00E-15 * Nx_scale;
    .ncn = 1.96;
    .ikr = 0.01 * Nx_scale;
    .wsp = 1;
    .isp = 4.00E-20 * Nx_scale;
    .nfp = 1.04;
    .ibcip = 2.00E-15 * pow(Nx_scale, 0.7);
    .ncip = 1.00;
    .ibcnp = 5.00E-15 * Nx_scale;
    .ncnp = 1.50;
    .ikp = 1.00E-04 * Nx_scale;
    .ibeip = 4.00E-19 * Nx_scale;
    .ibenp = 2.00E-14 * Nx_scale;
    .re = 7.13E+00 * pow(inv_Nx_scale, 1) * corner_hbt.vbic_re;
    .rcx = 1.3E+01 * pow(inv_Nx_scale, 1) * corner_hbt.vbic_rcx;
    .rci = 1.29E+01 * pow(inv_Nx_scale, 1);
    .qco = 1.00E-18;
    .vo = 0.80;
    .gamm = 2.25E-14;
    .hrcf = 1000;
    .rbx = 6.93E+00 * pow(inv_Nx_scale, 0.95) * corner_hbt.vbic_rbx;
    .rbi = 2.20E+01 * pow(inv_Nx_scale, 0.95) * corner_hbt.vbic_rbx;
    .rbp = 5.5 * inv_Nx_scale;
    .rs = 1;
    .avc1 = 2.40;
    .avc2 = 10.81;
    .tf = 2.08E-13 * corner_hbt.vbic_tf * pow($temperature / 300.0, 0.7);
    .qtf = 1.00E-18;
    .xtf = 10.0;
    .vtf = 20.0;
    .itf = 0.585 * Nx_scale;
    .tr = 3.50E-13;
    .td = sw_nqs * 2.80E-13 * pow(Nx_scale, 0);
    .cth = 1.60E-12 * pow(Nx_scale, 0.95);
    .rth = 1 * selft * 3.26E+03 * pow(inv_Nx_scale, 0.9);
    .ea = 1.056;
    .eaie = 1.056;
    .eaic = 1.12;
    .eais = 1.12;
    .eane = 1.12;
    .eanc = 1.12;
    .eans = 1.12;
    .xre = -0.42;
    .xrb = 0.90;
    .xrc = 0.245;
    .xrs = 1.50;
    .xvo = 1.50;
    .xis = 2.30;
    .xii = 3.30;
    .xin = 3.30;
    .tnf = 0.00015;
    .tavc = -0.00188;
    .kfn = 6.00E-9 * inv_Nx_scale;
    .afn = 1.80;
    .bfn = 1.00;
endparamset

(* desc="npn13G2 vbic13_4t paramset, with mismatch" *)
paramset npn13G2_NX_vbic vbic13_4t
    (* desc = "Number of emitter fingers" *)
    parameter integer Nx = 1 from [1:10];
    (* desc = "Temperature offset w.r.t. ambient temperature" *)
    parameter real dtemp = 0.0;
    (* desc = "Enable self-heating" *)
    parameter real selft = 1.0;
    (* desc = "Enable non-quasi-static model" *)
    parameter integer sw_nqs = 0 from [0:1];
    (* desc = "Enable mismatch" *)
    parameter integer mm_ok = 1 from [1:1];

    localparam real Nx_scale = 0.25 * Nx;
    localparam real inv_Nx_scale = 1.0 / Nx_scale;
    // local mismatch parameters
    localparam real mm_scale = 1.0 / sqrt(Nx);
    localparam real mm_vbic_cje =  mm_scale * $rdist_normal(1, 0.0, 0.017, "instance");
    localparam real mm_vbic_cjc  = mm_scale * $rdist_normal(2, 0.0, 0.010, "instance");
    localparam real mm_vbic_cjcp = mm_scale * $rdist_normal(3, 0.0, 0.028, "instance");
    localparam real mm_vbic_is   = mm_scale * $rdist_normal(4, 0.0, 0.038, "instance");
    localparam real mm_vbic_ibei = mm_scale * $rdist_normal(5, 0.0, 0.130, "instance");
    localparam real mm_vbic_re   = mm_scale * $rdist_normal(6, 0.0, 0.055, "instance");
    localparam real mm_vbic_rcx  = mm_scale * $rdist_normal(7, 0.0, 0.010, "instance");
    localparam real mm_vbic_rbx  = mm_scale * $rdist_normal(8, 0.0, 0.010, "instance");
    localparam real mm_vbic_tf   = mm_scale * $rdist_normal(9, 0.0, 0.010, "instance");

    .trise = dtemp;
    .tnom = 27;
    .cbeo = 8.00E-16 * pow(Nx_scale, 0.975);
    .cje = 8.418E-15 * pow(Nx_scale, 0.975) * corner_hbt.vbic_cje * (1 + mm_vbic_cje);
    .pe = 0.92;
    .me = 0.12;
    .aje = -0.50;
    .wbe = 1.00;
    .cbco = 2.36E-15 * Nx_scale;
    .cjc = 1.53E-15 * Nx_scale * corner_hbt.vbic_cjc * (1 + mm_vbic_cjc);
    .pc = 0.558;
    .mc = 0.12;
    .ajc = -0.50;
    .cjep = 3.56E-15 * Nx_scale * corner_hbt.vbic_cjc;
    .cjcp = 4.56E-15 * pow(Nx_scale, 0.8) * corner_hbt.vbic_cjcp * (1 + mm_vbic_cjcp);
    .ps = 0.46;
    .ms = 0.23;
    .ajs = -0.50;
    .fc = 0.80;
    .vef = 189;
    .ver = 5.3;
    .is = 4.81E-17 * Nx_scale * corner_hbt.vbic_is * (1 + mm_vbic_is);
    .nf = 1.018;
    .ibei = 1.9E-19 * Nx_scale * corner_hbt.vbic_ibei * (1 + mm_vbic_ibei);
    .nei = 1.066;
    .iben = 4.00E-16 * Nx_scale;
    .nen = 2.00;
    .ikf = 0.009 * Nx_scale;
    .nr = 1.01;
    .ibci = 1.50E-20 * Nx_scale;
    .nci = 1.103;
    .ibcn = 1.00E-15 * Nx_scale;
    .ncn = 1.96;
    .ikr = 0.01 * Nx_scale;
    .wsp = 1;
    .isp = 4.00E-20 * Nx_scale;
    .nfp = 1.04;
    .ibcip = 2.00E-15 * pow(Nx_scale, 0.7);
    .ncip = 1.00;
    .ibcnp = 5.00E-15 * Nx_scale;
    .ncnp = 1.50;
    .ikp = 1.00E-04 * Nx_scale;
    .ibeip = 4.00E-19 * Nx_scale;
    .ibenp = 2.00E-14 * Nx_scale;
    .re = 7.13E+00 * pow(inv_Nx_scale, 1) * corner_hbt.vbic_re * (1 + mm_vbic_re);
    .rcx = 1.3E+01 * pow(inv_Nx_scale, 1) * corner_hbt.vbic_rcx * (1 + mm_vbic_rcx);
    .rci = 1.29E+01 * pow(inv_Nx_scale, 1);
    .qco = 1.00E-18;
    .vo = 0.80;
    .gamm = 2.25E-14;
    .hrcf = 1000;
    .rbx = 6.93E+00 * pow(inv_Nx_scale, 0.95) * corner_hbt.vbic_rbx * (1 + mm_vbic_rbx);
    .rbi = 2.20E+01 * pow(inv_Nx_scale, 0.95) * corner_hbt.vbic_rbx;
    .rbp = 5.5 * inv_Nx_scale;
    .rs = 1;
    .avc1 = 2.40;
    .avc2 = 10.81;
    .tf = 2.08E-13 * corner_hbt.vbic_tf * (1 + mm_vbic_tf) * pow($temperature / 300.0, 0.7);
    .qtf = 1.00E-18;
    .xtf = 10.0;
    .vtf = 20.0;
    .itf = 0.585 * Nx_scale;
    .tr = 3.50E-13;
    .td = sw_nqs * 2.80E-13 * pow(Nx_scale, 0);
    .cth = 1.60E-12 * pow(Nx_scale, 0.95);
    .rth = 1 * selft * 3.26E+03 * pow(inv_Nx_scale, 0.9);
    .ea = 1.056;
    .eaie = 1.056;
    .eaic = 1.12;
    .eais = 1.12;
    .eane = 1.12;
    .eanc = 1.12;
    .eans = 1.12;
    .xre = -0.42;
    .xrb = 0.90;
    .xrc = 0.245;
    .xrs = 1.50;
    .xvo = 1.50;
    .xis = 2.30;
    .xii = 3.30;
    .xin = 3.30;
    .tnf = 0.00015;
    .tavc = -0.00188;
    .kfn = 6.00E-9 * inv_Nx_scale;
    .afn = 1.80;
    .bfn = 1.00;
endparamset
