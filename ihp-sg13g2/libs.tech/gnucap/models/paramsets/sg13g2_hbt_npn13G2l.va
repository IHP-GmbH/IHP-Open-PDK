// without mismatch
paramset npn13G2l_NX_vbic vbic13_4t
    parameter integer mm_ok = 0 from [0:0];
    parameter integer Nx = 1 from [1:4];
    parameter real El = 2.5 from [1:2.5];
    parameter real dtemp = 0.0;
    parameter real selft = 1.0;
    parameter integer sw_nqs = 0 from [0:1];
    localparam real Nx_scale = 0.25 * Nx;
    localparam real inv_Nx_scale = 1.0 / Nx_scale;
    localparam real El_norm = El / 2.5;
    localparam real inv_El_norm = 1.0 / El_norm;

    .trise = dtemp;
    .tnom = 27;
    .cbeo = 1.92E-15 * pow(El_norm, 0.85) * pow(Nx_scale, 0.95);
    .cje = 2.166E-14 * pow(El_norm, 0.85) * pow(Nx_scale, 0.95) * corner_hbt.vbic_cje;
    .pe = 0.92;
    .me = 0.12;
    .aje = -0.50;
    .wbe = 1.00;
    .cbco = 6.33E-15 * pow(El_norm, 0.85) * pow(Nx_scale, 0.975);
    .cjc = 3.83E-15 * pow(El_norm, 0.85) * pow(Nx_scale, 0.975) * corner_hbt.vbic_cjc;
    .pc = 0.558;
    .mc = 0.12;
    .ajc = -0.50;
    .cjep = 7.77E-15 * pow(El_norm, 0.85) * pow(Nx_scale, 0.975) * corner_hbt.vbic_cjc;
    .cjcp = 8.36E-15 * pow(El_norm, 0.55) * pow(Nx_scale, 0.8) * corner_hbt.vbic_cjcp;
    .ps = 0.46;
    .ms = 0.23;
    .ajs = -0.50;
    .fc = 0.80;
    .vef = 189;
    .ver = 5.3;
    .is = 7.50E-17 * pow(El_norm, 0.85) * Nx_scale * corner_hbt.vbic_is;
    .nf = 1.004;
    .ibei = 2.01E-19 * pow(El_norm, 0.85) * Nx_scale * corner_hbt.vbic_ibei;
    .nei = 1.035;
    .iben = 1.20E-15*pow(El_norm, 0.85) * Nx_scale;
    .nen = 2.00;
    .ikf = 0.032 * El_norm * Nx_scale;
    .nr = 1.01;
    .ibci = 3.00E-19 * El_norm * Nx_scale;
    .nci = 1.050;
    .ibcn = 1.00E-15 * El_norm * Nx_scale;
    .ncn = 1.70;
    .ikr = 0.01 * El_norm * Nx_scale;
    .wsp = 1;
    .isp = 4.00E-20 * El_norm * Nx_scale;
    .nfp = 1.04;
    .ibcip = 2.00E-15 * El_norm * pow(Nx_scale, 0.7);
    .ncip = 1.00;
    .ibcnp = 5.00E-15 * El_norm * Nx_scale;
    .ncnp = 1.50;
    .ikp = 1.00E-04 * El_norm * Nx_scale;
    .ibeip = 4.00E-19 * El_norm * Nx_scale;
    .ibenp = 2.00E-14 * El_norm * Nx_scale;
    .re = 3.19E+00 * inv_El_norm * pow(inv_Nx_scale, 0.88) * corner_hbt.vbic_re;
    .rcx = 3.90E+00 * inv_El_norm * pow(inv_Nx_scale, 0.9) * corner_hbt.vbic_rcx;
    .rci = 7.50E+00 * pow(inv_El_norm, 0.85) * pow(inv_Nx_scale, 1);
    .qco = 1.00E-18;
    .vo = 0.80;
    .gamm = 3.00E-14;
    .hrcf = 1000;
    .rbx = 2.54E+00 * pow(inv_El_norm, 0.7) * inv_Nx_scale * corner_hbt.vbic_rbx;
    .rbi = 7.26E+00 * pow(inv_El_norm, 0.7) * inv_Nx_scale;
    .rbp = 15.0 * pow(inv_El_norm, 0.7) * inv_Nx_scale;
    .rs = 1 * inv_El_norm * inv_Nx_scale;
    .avc1 = 2.40;
    .avc2 = 10.81;
    .tf = 2.31E-13 * pow(El_norm, 0.15) * corner_hbt.vbic_tf * pow($temperature / 300.0, 0.7);
    .qtf = 1.00E-18;
    .xtf = 10.0;
    .vtf = 20.0;
    .itf = 1.658 * El_norm * Nx_scale;
    .tr = 5.00E-13;
    .td = sw_nqs * 2.8e-13 * El_norm;
    .cth = 4.18E-12 * pow(El_norm, 0.8) * pow(Nx_scale, 0.8);
    .rth = selft * 1.63E+03 * pow(inv_El_norm, 0.85) * pow(inv_Nx_scale, 0.8);
    .ea = 1.045;
    .eaie = 1.078;
    .eaic = 1.12;
    .eais = 1.12;
    .eane = 1.12;
    .eanc = 1.12;
    .eans = 1.12;
    .xre = -0.42;
    .xrb = 0.90;
    .xrc = 0.420;
    .xrs = 1.50;
    .xvo = 1.50;
    .xis = 2.30;
    .xii = 3.30;
    .xin = 3.30;
    .tnf = 0.00015;
    .tavc = -0.00188;
    .kfn = 3.00E-9 * inv_El_norm * inv_Nx_scale;
    .afn = 1.80;
    .bfn = 1.00;
endparamset

// with mismatch
paramset npn13G2l_NX_vbic vbic13_4t
    parameter integer mm_ok = 1 from [1:1];
    parameter integer Nx = 1 from [1:4];
    parameter real El = 2.5 from [1:2.5];
    parameter real dtemp = 0.0;
    parameter real selft = 1.0;
    parameter integer sw_nqs = 0 from [0:1];
    localparam real Nx_scale = 0.25 * Nx;
    localparam real inv_Nx_scale = 1.0 / Nx_scale;
    localparam real El_norm = El / 2.5;
    localparam real inv_El_norm = 1.0 / El_norm;
    // mismatch
    localparam real mm_scale = 1.0 / sqrt(Nx);
    localparam real mm_vbic_cje =  mm_scale * $rdist_normal(1, 0.0, 0.017, "instance");
    localparam real mm_vbic_cjc  = mm_scale * $rdist_normal(2, 0.0, 0.010, "instance");
    localparam real mm_vbic_cjcp = mm_scale * $rdist_normal(3, 0.0, 0.028, "instance");
    localparam real mm_vbic_is   = mm_scale * $rdist_normal(4, 0.0, 0.038, "instance");
    localparam real mm_vbic_ibei = mm_scale * $rdist_normal(5, 0.0, 0.130, "instance");
    localparam real mm_vbic_re   = mm_scale * $rdist_normal(6, 0.0, 0.055, "instance");
    localparam real mm_vbic_rcx  = mm_scale * $rdist_normal(7, 0.0, 0.010, "instance");
    localparam real mm_vbic_rbx  = mm_scale * $rdist_normal(8, 0.0, 0.010, "instance");
    localparam real mm_vbic_tf   = mm_scale * $rdist_normal(9, 0.0, 0.010, "instance");
    .trise = dtemp;
    .tnom = 27;
    .cbeo = 1.92E-15 * pow(El_norm, 0.85) * pow(Nx_scale, 0.95);
    .cje = 2.166E-14 * pow(El_norm, 0.85) * pow(Nx_scale, 0.95) * corner_hbt.vbic_cje * (1 + mm_vbic_cje);
    .pe = 0.92;
    .me = 0.12;
    .aje = -0.50;
    .wbe = 1.00;
    .cbco = 6.33E-15 * pow(El_norm, 0.85) * pow(Nx_scale, 0.975);
    .cjc = 3.83E-15 * pow(El_norm, 0.85) * pow(Nx_scale, 0.975) * corner_hbt.vbic_cjc * (1 + mm_vbic_cjc);
    .pc = 0.558;
    .mc = 0.12;
    .ajc = -0.50;
    .cjep = 7.77E-15 * pow(El_norm, 0.85) * pow(Nx_scale, 0.975) * corner_hbt.vbic_cjc;
    .cjcp = 8.36E-15 * pow(El_norm, 0.55) * pow(Nx_scale, 0.8) * corner_hbt.vbic_cjcp * (1 + mm_vbic_cjcp);
    .ps = 0.46;
    .ms = 0.23;
    .ajs = -0.50;
    .fc = 0.80;
    .vef = 189;
    .ver = 5.3;
    .is = 7.50E-17 * pow(El_norm, 0.85) * Nx_scale * corner_hbt.vbic_is * (1 + mm_vbic_is);
    .nf = 1.004;
    .ibei = 2.01E-19 * pow(El_norm, 0.85) * Nx_scale * corner_hbt.vbic_ibei * (1 + mm_vbic_ibei);
    .nei = 1.035;
    .iben = 1.20E-15*pow(El_norm, 0.85) * Nx_scale;
    .nen = 2.00;
    .ikf = 0.032 * El_norm * Nx_scale;
    .nr = 1.01;
    .ibci = 3.00E-19 * El_norm * Nx_scale;
    .nci = 1.050;
    .ibcn = 1.00E-15 * El_norm * Nx_scale;
    .ncn = 1.70;
    .ikr = 0.01 * El_norm * Nx_scale;
    .wsp = 1;
    .isp = 4.00E-20 * El_norm * Nx_scale;
    .nfp = 1.04;
    .ibcip = 2.00E-15 * El_norm * pow(Nx_scale, 0.7);
    .ncip = 1.00;
    .ibcnp = 5.00E-15 * El_norm * Nx_scale;
    .ncnp = 1.50;
    .ikp = 1.00E-04 * El_norm * Nx_scale;
    .ibeip = 4.00E-19 * El_norm * Nx_scale;
    .ibenp = 2.00E-14 * El_norm * Nx_scale;
    .re = 3.19E+00 * inv_El_norm * pow(inv_Nx_scale, 0.88) * corner_hbt.vbic_re * (1 + mm_vbic_re);
    .rcx = 3.90E+00 * inv_El_norm * pow(inv_Nx_scale, 0.9) * corner_hbt.vbic_rcx * (1 + mm_vbic_rcx);
    .rci = 7.50E+00 * pow(inv_El_norm, 0.85) * pow(inv_Nx_scale, 1);
    .qco = 1.00E-18;
    .vo = 0.80;
    .gamm = 3.00E-14;
    .hrcf = 1000;
    .rbx = 2.54E+00 * pow(inv_El_norm, 0.7) * inv_Nx_scale * corner_hbt.vbic_rbx * (1 + mm_vbic_rbx);
    .rbi = 7.26E+00 * pow(inv_El_norm, 0.7) * inv_Nx_scale;
    .rbp = 15.0 * pow(inv_El_norm, 0.7) * inv_Nx_scale;
    .rs = 1 * inv_El_norm * inv_Nx_scale;
    .avc1 = 2.40;
    .avc2 = 10.81;
    .tf = 2.31E-13 * pow(El_norm, 0.15) * corner_hbt.vbic_tf * (1 + mm_vbic_tf) * pow($temperature / 300.0, 0.7);
    .qtf = 1.00E-18;
    .xtf = 10.0;
    .vtf = 20.0;
    .itf = 1.658 * El_norm * Nx_scale;
    .tr = 5.00E-13;
    .td = sw_nqs * 2.8e-13 * El_norm;
    .cth = 4.18E-12 * pow(El_norm, 0.8) * pow(Nx_scale, 0.8);
    .rth = selft * 1.63E+03 * pow(inv_El_norm, 0.85) * pow(inv_Nx_scale, 0.8);
    .ea = 1.045;
    .eaie = 1.078;
    .eaic = 1.12;
    .eais = 1.12;
    .eane = 1.12;
    .eanc = 1.12;
    .eans = 1.12;
    .xre = -0.42;
    .xrb = 0.90;
    .xrc = 0.420;
    .xrs = 1.50;
    .xvo = 1.50;
    .xis = 2.30;
    .xii = 3.30;
    .xin = 3.30;
    .tnf = 0.00015;
    .tavc = -0.00188;
    .kfn = 3.00E-9 * inv_El_norm * inv_Nx_scale;
    .afn = 1.80;
    .bfn = 1.00;
endparamset
