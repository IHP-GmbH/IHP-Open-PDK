// without mismatch
paramset npn13G2v_NX_vbic vbic13_4t
    parameter integer mm_ok = 0 from [0:0];
    parameter integer Nx = 1 from [1:4];
    parameter real El = 2.5 from [1:5];
    parameter real dtemp = 0.0;
    parameter real selft = 1.0;
    parameter integer sw_nqs = 0 from [0:1];
    localparam real Nx_scale = 0.25 * Nx;
    localparam real inv_Nx_scale = 1.0 / Nx_scale;
    localparam real El_norm = El / 2.5;
    localparam real inv_El_norm = 1.0 / El_norm;

    .trise = dtemp;
    .tnom = 27;
    .cbeo = 2.28E-15 * pow(El_norm, 0.94) * pow(Nx_scale, 0.95);
    .cje = 2.594E-14 * pow(El_norm, 0.94) * pow(Nx_scale, 0.95) * corner_hbt.vbic_cje;
    .pe = 0.88;
    .me = 0.13;
    .aje = -0.50;
    .wbe = 1.00;
    .cbco = 4.37E-15 * pow(El_norm, 0.85) * pow(Nx_scale, 0.975);
    .cjc = 2.52E-15 * pow(El_norm, 0.85) * pow(Nx_scale, 0.975) * corner_hbt.vbic_cjc;
    .pc = 0.397;
    .mc = 0.09;
    .ajc = -0.50;
    .cjep = 6.48E-15 * pow(El_norm, 0.85) * pow(Nx_scale, 0.975) * corner_hbt.vbic_cjc;
    .cjcp = 7.60E-15 * pow(El_norm, 0.65) * pow(Nx_scale, 0.5) * corner_hbt.vbic_cjcp;
    .ps = 0.31;
    .ms = 0.16;
    .ajs = -0.50;
    .fc = 0.80;
    .vef = 189;
    .ver = 5.3;
    .is = 1.22E-16 * pow(El_norm, 0.8) * Nx_scale * corner_hbt.vbic_is;
    .nf = 1.016;
    .ibei = 3.02E-19 * pow(El_norm, 0.925) * Nx_scale * corner_hbt.vbic_ibei;
    .nei = 1.043;
    .iben = 1.44E-15 * pow(El_norm, 0.925) * Nx_scale;
    .nen = 2.00;
    .ikf = 0.022 * El_norm * Nx_scale;
    .nr = 1.01;
    .ibci = 7.50E-19 * El_norm * Nx_scale;
    .nci = 1.050;
    .ibcn = 1.00E-15 * El_norm * Nx_scale;
    .ncn = 1.70;
    .ikr = 0.01 * El_norm * Nx_scale;
    .wsp = 1;
    .isp = 4.00E-20 * El_norm * Nx_scale;
    .nfp = 1.04;
    .ibcip = 2.00E-15 * El_norm * pow(Nx_scale, 0.7);
    .ncip = 1.00;
    .ibcnp = 5.00E-15 * El_norm * Nx_scale;
    .ncnp = 1.50;
    .ikp = 1.00E-04 * El_norm * Nx_scale;
    .ibeip = 4.00E-19 * El_norm * Nx_scale;
    .ibenp = 2.00E-14 * El_norm * Nx_scale;
    .re = 3.30E+00 * inv_El_norm * pow(inv_Nx_scale, 0.88) * corner_hbt.vbic_re;
    .rcx = 1.30E+01 * inv_El_norm * pow(inv_Nx_scale, 0.9) * corner_hbt.vbic_rcx;
    .rci = 1.53E+02 * pow(inv_El_norm, 0.9) * inv_Nx_scale;
    .qco = 1.00E-18;
    .vo = 2.40;
    .gamm = 3.30E-12;
    .hrcf = 1000;
    .rbx = 1.54E+00 * pow(inv_El_norm, 0.75) * inv_Nx_scale * corner_hbt.vbic_rbx;
    .rbi = 6.60E+00 * pow(inv_El_norm, 0.75) * inv_Nx_scale * corner_hbt.vbic_rbx;
    .rbp = 6.5 * pow(inv_El_norm, 0.75) * inv_Nx_scale;
    .rs = 1 * inv_El_norm * inv_Nx_scale;
    .avc1 = 2.40;
    .avc2 = 17.14;
    .tf = 4.10E-13 * pow(El_norm, 0) * corner_hbt.vbic_tf * pow($temperature / 300.0, 0.7);
    .qtf = 1.00E-18;
    .xtf = 60.0;
    .vtf = 20.0;
    .itf = 0.390 * El_norm * Nx_scale;
    .tr = 1.50E-12;
    .td = sw_nqs * 5.60E-13 * El_norm;
    .cth = 4.40E-12 * pow(El_norm, 1) * pow(Nx_scale, 0.8);
    .rth = selft * 1.55E+03 * pow(inv_El_norm, 1) * pow(inv_Nx_scale, 0.88);
    .rth = selft * 1.55E+03 * pow(inv_El_norm, 1) * pow(inv_Nx_scale, 0.88);
    .ea = 1.030;
    .eaie = 1.056;
    .eaic = 1.12;
    .eais = 1.12;
    .eane = 1.12;
    .eanc = 1.12;
    .eans = 1.12;
    .xre = -0.35;
    .xrb = 0.90;
    .xrc = 0.175;
    .xrs = 1.50;
    .xvo = 1.50;
    .xis = 2.70;
    .xii = 3.00;
    .xin = 3.00;
    .tnf = 0.00015;
    .tavc = -0.00075;
    .kfn = 6.00E-7 * inv_El_norm * inv_Nx_scale;
    .afn = 2.20;
    .bfn = 1.00;
endparamset
