`include "disciplines.vams"

`define rsh_rhigh `rsh_rhigh_norm
`define rsh_rppd `rsh_rppd_norm
`define rsh_rsil `rsh_rsil_norm
`define res_area `res_area_norm
`define res_rpara `res_rpara_norm
