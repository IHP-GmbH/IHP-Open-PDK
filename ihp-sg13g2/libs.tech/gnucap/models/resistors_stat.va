`include "disciplines.vams"

`define rsh_rhigh ((0.0833 <= 0) || (1 <= 0) ? `rsh_rhigh_norm : $rdist_normal(_rdist_seed, `rsh_rhigh_norm, 0.0833 / 1))
`define rsh_rppd ((0.033 <= 0) || (1 <= 0) ? `rsh_rppd_norm : $rdist_normal(_rdist_seed, `rsh_rppd_norm, 0.033 / 1))
`define rsh_rsil ((0.0467 <= 0) || (1 <= 0) ? `rsh_rsil_norm : $rdist_normal(_rdist_seed, `rsh_rsil_norm, 0.0467 / 1))
`define res_area ((0.033 <= 0) || (1 <= 0) ? `res_area_norm : $rdist_normal(_rdist_seed, `res_area_norm, 0.033 / 1))
`define res_rpara ((0.067 <= 0) || (1 <= 0) ? `res_rpara_norm : $rdist_normal(_rdist_seed, `res_rpara_norm, 0.067 / 1))
