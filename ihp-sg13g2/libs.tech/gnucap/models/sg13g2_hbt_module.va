//******************************************************************************
//
// Copyright 2026 IHP PDK Authors
//
// Licensed under the Apache License, Version 2.0 (the "License");
// you may not use this file except in compliance with the License.
// You may obtain a copy of the License at
//
//    https://www.apache.org/licenses/LICENSE-2.0
//
// Unless required by applicable law or agreed to in writing, software
// distributed under the License is distributed on an "AS IS" BASIS,
// WITHOUT WARRANTIES OR CONDITIONS OF ANY KIND, either express or implied.
// See the License for the specific language governing permissions and
// limitations under the License.
//
//******************************************************************************

//******************************************************************************
// SG13G2 HBT modules
//
// Adapted from `ngspice/models/sg13g2_hbt_mod_*.lib`
//
// Modifications:
// - Removed el parameter; modules only expose scaled El parameter
// - Moved Ny and we to the end because they are not used
// - Model declarations are in `paramsets/sg13g2_hbt_npn13G2{l,v}.va`
//******************************************************************************

(* desc = "SG13G2 npn13G2 HBT module with fixed emitter length" *)
module npn13G2(c, b, e, bn);
    inout c, b, e, bn;
    electrical c, b, e, bn;

    // TODO: add internal thermal port
    electrical s1;

    (* desc = "Number of emitter fingers" *)
    parameter integer Nx = 1 from [1:10];
    (* desc = "Temperature offset w.r.t. ambient temperature" *)
    parameter real dtemp = 0;
    (* desc = "Enable self-heating" *)
    parameter real selft = 1;
    (* desc = "Enable non-quasi-static model" *)
    parameter integer sw_nqs = 0 from [0:1];
    (* desc = "Enable mismatch" *)
    parameter integer mm_ok = 0 from [0:1];
    // TODO: unused
    (* desc = "Number of base fingers" *)
    parameter integer Ny = 1;
    (* desc = "Emitter width", units = "m" *)
    parameter real we = 0.12e-6;

    localparam real R = 300 + 100 * Nx;
    localparam real C = 2.30E-14 - (1.50E-15 * Nx);

    // TODO: connect thermal port
    npn13G2_NX_vbic #( \
        .Nx(Nx), \
        .dtemp(dtemp), \
        .selft(selft), \
        .sw_nqs(sw_nqs), \
        .mm_ok(mm_ok)) \
    Qnpn13G2(c, b, e, s1);
    resistor #(.r(R)) Rsub(s1, bn);
    capacitor #(.c(C)) Csub(s1, bn);
    // TODO: add thermal resistor Rt t 0 R = 1e9
endmodule

(* desc = "SG13G2 npn13G2 HBT module with fixed emitter length and thermal port" *)
// TODO: support thermal ports in Gnucap
module npn13G2_5t(c, b, e, bn, t);
    inout c, b, e, bn, t;
    electrical c, b, e, bn;
    thermal t;

    electrical s1;

    (* desc = "Number of emitter fingers" *)
    parameter integer Nx = 1 from [1:10];
    (* desc = "Temperature offset w.r.t. ambient temperature" *)
    parameter real dtemp = 0;
    (* desc = "Enable self-heating" *)
    parameter real selft = 1;
    (* desc = "Enable non-quasi-static model" *)
    parameter integer sw_nqs = 0 from [0:1];
    (* desc = "Enable mismatch" *)
    parameter integer mm_ok = 0 from [0:1];
    // TODO: unused
    (* desc = "Number of base fingers" *)
    parameter integer Ny = 1;
    (* desc = "Emitter width", units = "m" *)
    parameter real we = 0.12e-6;

    localparam real R = 300 + 100 * Nx;
    localparam real C = 2.30E-14 - (1.50E-15 * Nx);

    npn13G2_NX_vbic #( \
        .Nx(Nx), \
        .dtemp(dtemp), \
        .selft(selft), \
        .sw_nqs(sw_nqs), \
        .mm_ok(mm_ok)) \
    Qnpn13G2(c, b, e, s1, t);
    resistor #(.r(R)) Rsub(s1, bn);
    capacitor #(.c(C)) Csub(s1, bn);
    // TODO: add thermal resistor Rt t 0 R = 1e9
endmodule

//--------------------npn13g2l----------------------------------------------------
// Model:                                VBIC (Rev.1.15)
// Date:                                 25.05.18
// Lot:                                  EDJ802
// WAFER:                                02
// CHIP Nr:                              3.3
// Device:                               npn13g2l_VBIC_Q118
// Emitter size (mask):                  Nx *(0.07 x El) �m^2 with Nx = 1 - 4, El = 1 - 2.5
// Maximum collector-to-emitter voltage: 1.6
// Measurement data:                     T356_EDJ802_W02_3.3
// Meas. Range forward gummel:           vbe = (0.3 - 1.04)V
// Meas. Range forward output:           vce = (0.4 - 2.0)V
// Nom. Temperature  (TNOM):             27 grd C
// Meas. Temperature (TEMP):             27 grd C
// Valid range for model
// ic: <(...Nx*El) A  vbe :(0.65 - 0.96) V  vce :(0.4 - 2.0) V
// Temp: -40�C - +125�C
// Valid numbers: Nx = 1 - 4, El = 1 - 2.5
// model card checked with SPECTRE 10.x and ADS2009U1
// ________________________________________________________________________

(* desc = "SG13G2 npn13G2l HBT module with variable emitter length" *)
module npn13G2l(c, b, e, bn);
    inout c, b, e, bn;
    electrical c, b, e, bn;

    // TODO: add internal thermal port
    electrical s1;

    (* desc = "Number of emitter fingers" *)
    parameter integer Nx = 1 from [1:4];
    (* desc = "Emitter length", units = "um" *)
    parameter real El = 2.5 from [1:2.5];
    (* desc = "Enable self-heating" *)
    parameter real selft = 1;
    (* desc = "Temperature offset w.r.t. ambient temperature" *)
    parameter real dtemp = 0;
    (* desc = "Enable non-quasi-static model" *)
    parameter integer sw_nqs = 0 from [0:1];
    (* desc = "Enable mismatch" *)
    parameter integer mm_ok = 0 from [0:1];
    // TODO: unused
    (* desc = "Number of base fingers" *)
    parameter integer Ny = 1;
    (* desc = "Emitter width", units = "m" *)
    parameter real we = 0.12e-6;

    localparam real El_norm = El / 2.5;
    localparam real R = (300 + (400 * Nx)) * pow(El_norm, 0.5);
    localparam real C = (1.70E-14 - (2.00E-15 * Nx)) * pow(El_norm, 0);

    // TODO: connect thermal port
    npn13G2l_NX_vbic #( \
        .Nx(Nx), \
        .El(El), \
        .dtemp(dtemp), \
        .selft(selft), \
        .sw_nqs(sw_nqs), \
        .mm_ok(mm_ok)) \
    Qnpn13G2l(c, b, e, s1);
    resistor #(.r(R)) Rsub(s1, bn);
    capacitor #(.c(C)) Csub(s1, bn);
    // TODO: add thermal resistor Rt t 0 R = 1e9
endmodule

(* desc = "SG13G2 npn13G2l HBT module with variable emitter length and thermal port" *)
// TODO: support thermal ports in Gnucap
module npn13G2l_5t(c, b, e, bn, t);
    inout c, b, e, bn, t;
    electrical c, b, e, bn;
    thermal t;

    electrical s1;

    (* desc = "Number of emitter fingers" *)
    parameter integer Nx = 1 from [1:4];
    (* desc = "Emitter length", units = "um" *)
    parameter real El = 2.5 from [1:2.5];
    (* desc = "Enable self-heating" *)
    parameter real selft = 1;
    (* desc = "Temperature offset w.r.t. ambient temperature" *)
    parameter real dtemp = 0;
    (* desc = "Enable non-quasi-static model" *)
    parameter integer sw_nqs = 0 from [0:1];
    (* desc = "Enable mismatch" *)
    parameter integer mm_ok = 0 from [0:1];
    // TODO: unused
    (* desc = "Number of base fingers" *)
    parameter integer Ny = 1;
    (* desc = "Emitter width", units = "m" *)
    parameter real we = 0.12e-6;

    localparam real El_norm = El / 2.5;
    localparam real R = (300 + (400 * Nx)) * pow(El_norm, 0.5);
    localparam real C = (1.70E-14 - (2.00E-15 * Nx)) * pow(El_norm, 0);

    // TODO: connect thermal port
    npn13G2l_NX_vbic #( \
        .Nx(Nx), \
        .El(El), \
        .dtemp(dtemp), \
        .selft(selft), \
        .sw_nqs(sw_nqs), \
        .mm_ok(mm_ok)) \
    Qnpn13G2l(c, b, e, s1, t);
    resistor #(.r(R)) Rsub(s1, bn);
    capacitor #(.c(C)) Csub(s1, bn);
    // TODO: add thermal resistor Rt t 0 R = 1e9
endmodule

//--------------------npn13g2v----------------------------------------------------
// Model:                                VBIC (Rev.1.15)
// Date:                                 25.05.18
// Lot:                                  EDJ802
// WAFER:                                02
// CHIP Nr:                              3.3
// Device:                               npn13g2v_VBIC_Q118
// Emitter size (mask):                  Nx *(0.12 x El) �m^2 with Nx = 1 - 4, El = 1.0 - 5.0
// Maximum collector-to-emitter voltage: 2.5
// Measurement data:                     T356_EDJ802_W02_3.3
// Meas. Range forward gummel:           vbe = (0.3 - 1.0)V
// Meas. Range forward output:           vce = (0 - 3.0)V
// Nom. Temperature  (TNOM):             27 grd C
// Meas. Temperature (TEMP):             27 grd C
// Valid range for model
// ic: <(0.50*Nx*El) A  vbe :(0.65 - 0.84) V  vce :(0.8 - 2.3) V
// Temp: -40�C - +125�C
// Valid numbers: Nx = 1 - 4, El = 1 - 5
// model card checked with SPECTRE 10.x and ADS2009U1
// ________________________________________________________________________

(* desc = "SG13G2 npn13G2v high-voltage HBT module with variable emitter length" *)
module npn13G2v(c, b, e, bn);
    inout c, b, e, bn;
    electrical c, b, e, bn;

    // TODO: add internal thermal port
    electrical s1;

    (* desc = "Number of emitter fingers" *)
    parameter integer Nx = 1 from [1:4];
    (* desc = "Emitter length", units = "um" *)
    parameter real El = 2.5 from [1:5];
    (* desc = "Enable self-heating" *)
    parameter real selft = 1;
    (* desc = "Temperature offset w.r.t. ambient temperature" *)
    parameter real dtemp = 0;
    (* desc = "Enable non-quasi-static model" *)
    parameter integer sw_nqs = 0 from [0:1];
    (* desc = "Enable mismatch" *)
    parameter integer mm_ok = 0 from [0:1];
    // TODO: unused
    (* desc = "Number of base fingers" *)
    parameter integer Ny = 1;
    (* desc = "Emitter width", units = "m" *)
    parameter real we = 0.12e-6;

    localparam real El_norm = El / 2.5;
    localparam real R = (300 + (400 * Nx)) * pow(El_norm, 0.85);
    localparam real C = (1.70E-14 - (2.00E-15 * Nx)) * pow(El_norm, 0);

    // TODO: connect thermal port
    npn13G2v_NX_vbic #( \
        .Nx(Nx), \
        .El(El), \
        .dtemp(dtemp), \
        .selft(selft), \
        .sw_nqs(sw_nqs), \
        .mm_ok(mm_ok)) \
    Qnpn13G2v(c, b, e, s1);
    resistor #(.r(R)) Rsub(s1, bn);
    capacitor #(.c(C)) Csub(s1, bn);
    // TODO: add thermal resistor Rt t 0 R = 1e9
endmodule

(* desc = "SG13G2 high-voltage HBT module with variable emitter length and thermal port" *)
// TODO: support thermal ports in Gnucap
module npn13G2v_5t(c, b, e, bn, t);
    inout c, b, e, bn, t;
    electrical c, b, e, bn;
    thermal t;

    electrical s1;

    (* desc = "Number of emitter fingers" *)
    parameter integer Nx = 1 from [1:4];
    (* desc = "Emitter length", units = "um" *)
    parameter real El = 2.5 from [1:5];
    (* desc = "Enable self-heating" *)
    parameter real selft = 1;
    (* desc = "Temperature offset w.r.t. ambient temperature" *)
    parameter real dtemp = 0;
    (* desc = "Enable non-quasi-static model" *)
    parameter integer sw_nqs = 0 from [0:1];
    (* desc = "Enable mismatch" *)
    parameter integer mm_ok = 0 from [0:1];
    // TODO: unused
    (* desc = "Number of base fingers" *)
    parameter integer Ny = 1;
    (* desc = "Emitter width", units = "m" *)
    parameter real we = 0.12e-6;

    localparam real El_norm = El / 2.5;
    localparam real R = (300 + (400 * Nx)) * pow(El_norm, 0.85);
    localparam real C = (1.70E-14 - (2.00E-15 * Nx)) * pow(El_norm, 0);

    npn13G2v_NX_vbic #( \
        .Nx(Nx), \
        .El(El), \
        .dtemp(dtemp), \
        .selft(selft), \
        .sw_nqs(sw_nqs), \
        .mm_ok(mm_ok)) \
    Qnpn13G2v(c, b, e, s1, t);
    resistor #(.r(R)) Rsub(s1, bn);
    capacitor #(.c(C)) Csub(s1, bn);
    // TODO: add thermal resistor Rt t 0 R = 1e9
endmodule
