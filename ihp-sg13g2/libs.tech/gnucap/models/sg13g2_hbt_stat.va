`include "disciplines.vams"

`define vbic_cje (`vbic_cje_norm)
`define vbic_cjc (`vbic_cjc_norm)
`define vbic_cjcp (`vbic_cjcp_norm)
`define vbic_is (`vbic_is_norm)
`define vbic_ibei (`vbic_ibei_norm)
`define vbic_re (`vbic_re_norm)
`define vbic_rcx (`vbic_rcx_norm)
`define vbic_rbx (`vbic_rbx_norm)
`define sgp_mpa_cje (`sgp_mpa_cje_norm)
`define sgp_mpa_cjc (`sgp_mpa_cjc_norm)
`define sgp_mpa_is (`sgp_mpa_is_norm)
`define sgp_mpa_bf (`sgp_mpa_bf_norm)
`define sgp_mpa_re (`sgp_mpa_re_norm)
`define sgp_mpa_rb (`sgp_mpa_rb_norm)
`define sgp_mpa_rc (`sgp_mpa_rc_norm)
