//******************************************************************************
//                                                                             *
// Library:      SG13G2_dev                                                    *
// Technologies: SG13G2                                                        *
//                                                                             *
// Model:        PSP 108.3.2                                                   *
// Revision:     200310                                                        *
//                                                                             *
//******************************************************************************
//                                                                             *
// Copyright 2023 IHP PDK Authors                                              *
//                                                                             *
// Licensed under the Apache License, Version 2.0 (the "License");             *
// you may not use this file except in compliance with the License.            *
// You may obtain a copy of the License at                                     *
//                                                                             *
//     https://www.apache.org/licenses/LICENSE-2.0                             *
//                                                                             *
// Unless required by applicable law or agreed to in writing, software         *
// distributed under the License is distributed on an "AS IS" BASIS,           *
// WITHOUT WARRANTIES OR CONDITIONS OF ANY KIND, either express or implied.    *
// See the License for the specific language governing permissions and         *
// limitations under the License.                                              *
//                                                                             *
//******************************************************************************
//******************************************************************************
//                                                                             *
//                                                                             *
//              C O M M O N    SG 13  M O S     M O D E L S                    *
//                                                                             *
//                                                                             *
//******************************************************************************
//
// NOTE: do not include this file directly in the netlist, use models.typ, .bcs or .wcs only
//
//
//
//******************************************************************************
// variable C section
//******************************************************************************
//
//
//******************************************************************************
// MOS transistor section
//******************************************************************************

// MOS-Subckt with D/S-overlap possibility
//
//       z1              z2            z1
//   ----------------------------------------
//   |          |   |         |   |         |
//   |    S     | G |   D     | G |    S    |  w/ng, >=0.15u
//   |          |   |         |   |         |
//   ----------------------------------------
//
//  z1=0.34u, z2=0.38u
//
// Parameters as,ad,ps,pd are calculated automatically, if <= 0
//
// NOTE:
// values are one-sigma deviations (1/3 of min-max)

// if as = 0, calculate value, else take it
// if as is given externally, no adjustment for ng is done! -> must be done in the extractor
// if ng>1 and as=0 (in schematic) recalculate!

//******************************************************************************

// sg13g2_hv modules
// Ported from `ngspice/models/sg13g2_moshv_mod*.lib`to Verilog-A
// Modifications:
// - replace conditional branches with localparams
// - hardcoded mismatch parameters from `sg13g2_moshv_mismatch.lib` directly into
//   `rdist_normal` functions calls
// (c) Lukas Deutz 2026

// TODO: change from modules to paramsets as soon as nesting is supported in Gnucap
// TODO: rename sg13_hv_nmos_TODO and sg13_hv_pmos_TODO modules

//******************************************************************************
// NMOS
//******************************************************************************

// -----------------------------------------------------------------------------
// if as, ad, pd, ps parameters are not passed by users, calculate

// without mismatch
module sg13_hv_nmos(d, g, s, b);
    parameter real w = 0.3u from [0.3u:10u];
    parameter real l = 0.45u from [0.45u:10u];
    parameter integer ng = 1 from [1:1000);
    parameter real m = 1.0;
    parameter integer mm_ok = 0 from [0:0];
    parameter real trise = 0.0;
    parameter real z1 = 0.34e-6;
    parameter real z2 = 0.38e-6;
    parameter real pre_layout = 1.0;
    parameter integer rfmode = 0 from [0:1]; // 0=PSP, 1=PSP_NQS
    localparam real wmin = 0.35e-6;
    localparam real mw = max(w / ng, wmin);
    localparam integer k = ng / 2;
    localparam integer p = ng % 2;
    localparam real as = mw * ((2 - p) * z1 + (k - 1 + p) * z2);
    localparam real ad = mw * (p * z1 + k * z2);
    localparam real pd = 2 * (mw * (k + 1) + (2 - p) * z1 + (k - 1 + p) * z2);
    localparam real ps = 2 * (mw * (k + p) + p * z1 + k * z2);
    electrical d,g,s,b;
    // TODO: linebreak when supported
    sg13g2_hv_nmos_psp #(.rfmode(rfmode), .w(w), .l(l), .ng(ng), .mult(m), .as(as), .ad(ad), .ps(ps), .pd(pd), .dta(trise), .ngcon(2), .delvto(0), .factuo(1)) Nsg13_hv_nmos(d, g, s, b);
endmodule

// with mismatch
module sg13_hv_nmos(d, g, s, b);
    parameter real w = 0.3u from [0.3u:10u];
    parameter real l = 0.45u from [0.45u:10u];
    parameter integer ng = 1 from [1:1000); // TODO: upper inf bound doesn't work for integers
    parameter real m = 1.0;
    parameter integer mm_ok = 1 from [1:1];
    parameter real trise = 0.0;
    parameter real z1 = 0.34e-6;
    parameter real z2 = 0.38e-6;
    parameter real pre_layout = 1.0;
    parameter integer rfmode = 0 from [0:1]; // 0=PSP, 1=PSP_NQS
    localparam real wmin = 0.35e-6;
    localparam real w_mm = $rdist_normal(1, w, 3e-9, "instance");
    localparam real l_mm = $rdist_normal(2, l, 3e-9, "instance");
    localparam real mw = max(w_mm / ng, wmin);
    localparam integer k = ng / 2;
    localparam integer p = ng % 2;
    localparam real as = mw * ((2 - p) * z1 + (k - 1 + p) * z2);
    localparam real ad = mw * (p * z1 + k * z2);
    localparam real pd = 2 * (mw * (k + 1) + (2 - p) * z1 + (k - 1 + p) * z2);
    localparam real ps = 2 * (mw * (k + p) + p * z1 + k * z2);
    localparam real area_um2 = m * l_mm * w_mm * 1e12;
    localparam real delvto_sig = 0.007 / sqrt(area_um2);
    localparam real factuo_sig = 0.005 / sqrt(area_um2);
    localparam real delvto = $rdist_normal(2, 0, delvto_sig, "instance");
    localparam real factuo = $rdist_normal(3, 1, factuo_sig, "instance");
    electrical d,g,s,b;
    // TODO: linebreak when supported
    sg13g2_hv_nmos_psp #(.rfmode(rfmode), .w(w_mm), .l(l_mm), .ng(ng), .mult(m), .as(as), .ad(ad), .ps(ps), .pd(pd), .dta(trise), .ngcon(2), .delvto(delvto), .factuo(factuo)) Nsg13_hv_nmos(d, g, s, b);
endmodule
// -----------------------------------------------------------------------------

// -----------------------------------------------------------------------------
// if as, ad, pd, ps are passed by user, forward

// without mismatch
 module sg13_hv_nmos_TODO(d, g, s, b);
    parameter real w = 0.3u from [0.3u:10u];
    parameter real l = 0.45u from [0.45u:10u];
    parameter integer ng = 1 from [1:1000); // TODO: upper inf bound doesn't work for integers
    parameter real m = 1.0;
    parameter integer mm_ok = 0 from [0:0];
    parameter real trise = 0.0;
    parameter real as = 0.0; // from [0:inf);
    parameter real ad = 0.0; // from [0:inf);
    parameter real pd = 0.0; // from [0:inf);
    parameter real ps = 0.0; // from [0:inf);
    parameter real pre_layout = 1;
    parameter integer rfmode = 0 from [0:1]; // 0=PSP, 1=PSP_NQS
    electrical d,g,s,b;
    // TODO: linebreak when supported
    sg13g2_hv_nmos_psp #(.rfmode(rfmode), .w(w), .l(l), .ng(ng), .mult(m), .as(as), .ad(ad), .ps(ps), .pd(pd), .dta(trise), .ngcon(2), .delvto(0), .factuo(1)) Nsg13_hv_nmos(d, g, s, b);
endmodule

// with mismatch
module sg13_lv_nmos_TODO(d, g, s, b);
    parameter real w = 0.3u from [0.3u:10u];
    parameter real l = 0.45u from [0.45u:10u];
    parameter integer ng = 1 from [1:1000); // TODO: upper inf bound doesn't work for integers
    parameter real m = 1;
    parameter integer mm_ok = 1 from [1:1];
    parameter real trise = 0.0;
    parameter as = 0.0; // from [0:inf];
    parameter ad = 0.0; // from [0:inf];
    parameter pd = 0.0; // from [0:inf];
    parameter ps = 0.0; // from [0:inf];
    parameter real pre_layout = 1;
    parameter integer rfmode = 0 from [0:1]; // 0=PSP, 1=PSP_NQS
    // local param
    localparam real w_mm = $rdist_normal(1, w, 3e-9, "instance");
    localparam real l_mm = $rdist_normal(2, l, 3e-9, "instance");
    localparam real delvto_sig = 0.007 / sqrt(area_um2);
    localparam real factuo_sig = 0.005 / sqrt(area_um2);
    localparam real delvto = $rdist_normal(2, 0, delvto_sig, "instance");
    localparam real factuo = $rdist_normal(3, 1, factuo_sig, "instance");
    electrical d,g,s,b;
    // TODO: line break when supported
    sg13g2_hv_nmos_psp #(.rfmode(rfmode), .w(w_mm), .l(l_mm), .ng(ng), .mult(m), .as(as), .ad(ad), .ps(ps), .pd(pd), .dta(trise), .ngcon(2), .delvto(delvto), .factuo(factuo)) Nsg13_hv_nmos(d, g, s, b);
endmodule

//******************************************************************************
// PMOS
//******************************************************************************

// -----------------------------------------------------------------------------
// if as, ad, pd, ps are not passed by users, calculate

// without mismatch
module sg13_hv_pmos(d, g, s, b);
    parameter real w = 0.3u from [0.3u:10u];
    parameter real l = 0.4u from [0.4u:10u];
    parameter integer ng = 1 from [1:1000); // TODO: upper inf bound doesn't work for integers;
    parameter real m = 1.0;
    parameter integer mm_ok = 0 from [0:0];
    parameter real trise = 0.0;
    parameter real z1 = 0.34e-6;
    parameter real z2 = 0.38e-6;
    parameter real pre_layout = 1.0;
    parameter integer rfmode = 0 from [0:1];
    localparam real wmin = 0.15e-6;
    localparam real mw = max(w / ng, wmin);
    localparam integer k = ng / 2;
    localparam integer p = ng % 2;
    localparam real as = mw * ((2 - p) * z1 + (k - 1 + p) * z2);
    localparam real ad = mw * (p * z1 + k * z2);
    localparam real pd = 2 * (mw * (k + 1) + (2 - p) * z1 + (k -1 + p) * z2);
    localparam real ps = 2 * (mw * (k + p) + p * z1 + k * z2);
    electrical d,g,s,b;
    // TODO: linebreak when supported
    sg13g2_hv_pmos_psp #(.rfmode(rfmode), .w(w), .l(l), .ng(ng), .mult(m), .as(as), .ad(ad), .ps(ps), .pd(pd), .dta(trise), .ngcon(2), .delvto(0), .factuo(1)) Nsg13_hv_pmos(d, g, s, b);
endmodule

// with mismatch
module sg13_hv_pmos(d, g, s, b);
    parameter real w = 0.3u from [0.3u:10u];
    parameter real l = 0.4u from [0.4u:10u];
    parameter integer ng = 1 from [1:1000); // TODO: upper inf bound doesn't work for integers
    parameter real m = 1.0;
    parameter integer mm_ok = 1 from [1:1];
    parameter real trise = 0.0;
    parameter real z1 = 0.34e-6;
    parameter real z2 = 0.38e-6;
    parameter real pre_layout = 1.0;
    parameter integer rfmode = 0 from [0:1];
    localparam real wmin = 0.15e-6;
    localparam real w_mm = $rdist_normal(1, w, 3e-9, "instance");
    localparam real l_mm = $rdist_normal(2, l, 3e-9, "instance");
    localparam real mw = max(w_mm / ng, wmin);
    localparam integer k = ng / 2;
    localparam integer p = ng % 2;
    localparam real as = mw * ((2 - p) * z1 + (k - 1 + p) * z2);
    localparam real ad = mw * (p * z1 + k * z2);
    localparam real pd = 2 * (mw * (k + 1) + (2 - p) * z1 + (k - 1 + p) * z2);
    localparam real ps = 2 * (mw * (k + p) + p * z1 + k * z2);
    localparam real area_um2 = m * l_mm * w_mm * 1e12;
    localparam real delvto_sig = 0.0045 / sqrt(area_um2);
    localparam real factuo_sig = 0.0040 / sqrt(area_um2);
    localparam real delvto = $rdist_normal(3, 0, delvto_sig, "instance");
    localparam real factuo = $rdist_normal(4, 1, factuo_sig, "instance");
    electrical d,g,s,b;
    // TODO: linebreak when supported
    sg13g2_hv_pmos_psp #(.rfmode(rfmode), .w(w_mm), .l(l_mm), .ng(ng), .mult(m), .as(as), .ad(ad), .ps(ps), .pd(pd), .dta(trise), .ngcon(2), .delvto(delvto), .factuo(factuo)) Nsg13_hv_pmos(d, g, s, b);
endmodule
// -----------------------------------------------------------------------------

// -----------------------------------------------------------------------------
// if as, ad, pd, ps are passed by user, forward

// without mismatch
module sg13_hv_pmos_TODO(d, g, s, b);
    parameter real w = 0.3u from [0.3u:10u];
    parameter real l = 0.4u from [0.4u:10u];
    parameter integer ng = 1 from [1:1000);
    parameter real m = 1;
    parameter integer mm_ok = 0 from [0:0];
    parameter real as = 0.0; // from [0:inf);
    parameter real ad = 0.0; // from [0:inf);
    parameter real pd = 0.0; // from [0:inf);
    parameter real ps = 0.0; // from [0:inf);
    parameter real trise = 0.0;
    parameter real pre_layout = 1;
    parameter integer rfmode = 0 from [0:1];
    electrical d, g, s, b;
    // TODO: linebreak when supported
    sg13g2_lv_pmos_psp #(.rfmode(rfmode), .w(w), .l(l), .ng(ng), .mult(m), .as(as), .ad(ad), .ps(ps), .pd(pd), .dta(trise), .ngcon(2), .delvto(0), .factuo(1)) Nsg13_lv_pmos(d, g, s, b);
endmodule

// with mismatch
module sg13_hv_pmos_TODO(d, g, s, b);
    parameter real w = 0.3u from [0.3u:10u];
    parameter real l = 0.4u from [0.4u:10u];
    parameter integer ng = 1 from [1:1000);
    parameter real m = 1;
    parameter integer mm_ok = 1 from [1:1];
    parameter real as = 0.0; // from [0:inf);
    parameter real ad = 0.0; // from [0:inf);
    parameter real pd = 0.0; // from [0:inf);
    parameter real ps = 0.0; // from [0:inf);
    parameter real trise = 0.0;
    parameter real pre_layout = 1;
    parameter integer rfmode = 0 from [0:1];
    localparam real w_mm = $rdist_normal(1, w, 3e-9);
    localparam real l_mm = $rdist_normal(2, l, 3e-9);
    localparam real area_um2 = m * l_mm * w_mm * 1e12;
    localparam real delvto_sig = 0.0045 / sqrt(area_um2);
    localparam real factuo_sig = 0.0040 / sqrt(area_um2);
    localparam real delvto = $rdist_normal(3, 0, delvto_sig, "instance");
    localparam real factuo = $rdist_normal(4, 1, factuo_sig, "instance");
    electrical d, g, s, b;
    // TODO: linebreak when supported
    sg13g2_lv_pmos_psp #(.rfmode(rfmode), .w(w_mm), .l(l_mm), .ng(ng), .mult(m), .as(as), .ad(ad), .ps(ps), .pd(pd), .dta(trise), .ngcon(2), .delvto(delvto), .factuo(factuo)) Nsg13_lv_pmos(d, g, s, b);
endmodule
//-----------------------------------------------------------------------------
