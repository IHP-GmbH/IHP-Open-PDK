//******************************************************************************
//                                                                             *
// Library:      Smoslv_modG13G2_dev                                           *
// Technologies: SG13G2                                                        *
//                                                                             *
// Model:        PSP 108.3.2                                                   *
// Revision:     210511                                                        *
//                                                                             *
//******************************************************************************
//                                                                             *
// Copyright 2023 IHP PDK Authors                                              *
//                                                                             *
// Licensed under the Apache License, Version 2.0 (the "License");             *
// you may not use this file except in compliance with the License.            *
// You may obtain a copy of the License at                                     *
//                                                                             *
//     https://www.apache.org/licenses/LICENSE-2.0                             *
//                                                                             *
// Unless required by applicable law or agreed to in writing, software         *
// distributed under the License is distributed on an "AS IS" BASIS,           *
// WITHOUT WARRANTIES OR CONDITIONS OF ANY KIND, either express or implied.    *
// See the License for the specific language governing permissions and         *
// limitations under the License.                                              *
//                                                                             *
//******************************************************************************
//
//
//******************************************************************************
//                                                                             *
//                                                                             *
//                      M O D E L  P A R A M E T E R S                         *
//                                                                             *
//                                                                             *
//******************************************************************************
//
//
//
//
//
//
//
//******************************************************************************
//
// High Voltage (hv) MOS Transistors
//
// Model:                                PSP 103.8.2
// Date:                                 10.03.2020
// Lot:                                  EDJ
// WAFER:                                06
// CHIP Nr:                              x=3, y=9
// Device:                               SG13G2
// Maximum drain-source voltage:         3.3
// Measurement data:
// Nom. Temperature  (TNOM):             27 grd C
// Meas. Temperature (TEMP):             27 grd C
// Valid range for model:                L = (0.45 - 10)um   nmos
//                                       L = (0.40 - 10)um   pmos
//                                       W = (0.30 - 10)um
//
//******************************************************************************

//******************************************************************************
// sg13g2_hv PSP103VA paramsets
// Ported from `ngspice/models/sg13g2_moshv_param`to Verilog-A
// Modifications:
// - added parameters to pass values from top-level wrapper paramsets
// - corner parameters are resolved through cross-reference from corner instance
//   named corner_moslv
// (c) Lukas Deutz 2026

`pragma modelgen nogen-module
`include "psp103.va"

// Generated from SPICE model card sg13g2_hv_nmos_psp in sg13g2_moshv_parm.lib
paramset sg13g2_hv_nmos_psp PSP103VA
    parameter integer rfmode = 0 from [0:0];
    parameter real w = 0.35u;
    parameter real l = 0.45u;
    parameter integer ng = 1;
    parameter real mult = 1.0;
    parameter real as = 0.0;
    parameter real ad = 0.0;
    parameter real ps = 0.0;
    parameter real pd = 0.0;
    parameter real dta = 0.0;
    parameter real ngcon = 1.0;
    parameter real delvto = 0.0;
    parameter real factuo = 1.0;
    parameter real pre_layout = 1.0;
    parameter real swsoa = 0.0;
    .LEVEL = 103.8.2;
    .TYPE = 1;
    .W = w;
    .L = l;
    .NF = ng;
    .MULT = mult;
    .AS = as;
    .AD = ad;
    .PS = ps;
    .PD = pd;
    .TR = 27.0;
    .DTA = dta;
    .NGCON = ngcon;
    .DELVTO = delvto;
    .FACTUO = factuo;
    .SWGEO = 1.0;
    .SWIGATE = 1.0;
    .SWIMPACT = 1.0;
    .SWGIDL = 0.0;
    .SWJUNCAP = 3.0;
    .SWJUNASYM = 0.0;
    .SWNUD = 0.0;
    .SWEDGE = 0.0;
    .SWDELVTAC = 0.0;
    .SWIGN = 1.0;
    .QMC = 1.0;
    .LVARO = 3.499e-08;
    .LVARL = -0.09125;
    .LVARW = 0.0;
    .LAP = 6.3866e-08;
    .WVARO = 0.0;
    .WVARL = 0.0;
    .WVARW = 0.0;
    .WOT = 3e-08;
    .DLQ = 5.2202e-08 - ((1 - pre_layout) * 0.0);
    .DWQ = 3e-08;
    .VFBO = -0.89839 * corner_moshv.sg13g2_hv_nmos_vfbo;
    .VFBL = 0.15096;
    .VFBW = 0.0017033;
    .VFBLW = 0.019398;
    .STVFBO = 0.0008739;
    .STVFBL = 0.00014864;
    .STVFBW = -4.6174e-05;
    .STVFBLW = -2.445e-06;
    .ST2VFBO = 0.0;
    .TOXO = 7.4256e-09 * corner_moshv.sg13g2_hv_nmos_toxo;
    .EPSROXO = 3.9;
    .NSUBO = 1.8552e+23;
    .NSUBW = -0.0050198;
    .WSEG = 1.098e-10;
    .NPCK = 3.178e+23;
    .NPCKW = -2.7604;
    .WSEGP = 1e-08;
    .LPCK = 1e-08;
    .LPCKW = 0.0;
    .FOL1 = 0.21033;
    .FOL2 = 0.0026472;
    .FACNEFFACO = 1.0;
    .FACNEFFACL = 0.0;
    .FACNEFFACW = 0.0;
    .FACNEFFACLW = 0.0;
    .GFACNUDO = 1.0;
    .GFACNUDL = 0.0;
    .GFACNUDLEXP = 1.0;
    .GFACNUDW = 0.0;
    .GFACNUDLW = 0.0;
    .VSBNUDO = 0.0;
    .DVSBNUDO = 1.0;
    .VNSUBO = 0.0;
    .NSLPO = 0.05;
    .DNSUBO = 0.025686;
    .DPHIBO = -0.042228 * corner_moshv.sg13g2_hv_nmos_dphibo;
    .DPHIBL = -0.0035715 * corner_moshv.sg13g2_hv_nmos_dphibl;
    .DPHIBLEXP = 2.3956;
    .DPHIBW = 0.014614 * corner_moshv.sg13g2_hv_nmos_dphibw;
    .DPHIBLW = -0.02006 * corner_moshv.sg13g2_hv_nmos_dphiblw;
    .DELVTACO = 0.0;
    .DELVTACL = 0.0;
    .DELVTACLEXP = 1.0;
    .DELVTACW = 0.0;
    .DELVTACLW = 0.0;
    .NPO = 3.897e+26;
    .NPL = -0.1215;
    .TOXOVO = 7.4256e-09 * corner_moshv.sg13g2_hv_nmos_toxovo;
    .TOXOVDO = 2e-09;
    .LOV = 6.3866e-08 -((1 - pre_layout) * 1e-08);
    .LOVD = 0.0;
    .NOVO = 5.5814e+24;
    .NOVDO = 5e+25;
    .CTO = -0.061658;
    .CTL = 0.025 * corner_moshv.sg13g2_hv_nmos_ctl;
    .CTLEXP = 1.6063;
    .CTW = -0.044911;
    .CTLW = -0.0077386;
    .CTGO = 0.0;
    .CTBO = 0.0;
    .STCTO = 1.0;
    .CFL = 0.0048288;
    .CFLEXP = 1.3328;
    .CFW = 0.037319;
    .CFBO = 0.26069;
    .CFDO = 0.0;
    .PSCEL = 0.0;
    .PSCELEXP = 2.0;
    .PSCEW = 0.0;
    .PSCEBO = 0.0;
    .PSCEDO = 0.0;
    .UO = 0.046687;
    .FBET1 = -0.35712;
    .FBET1W = -0.14995;
    .LP1 = 4.5615e-08;
    .LP1W = 0.4189;
    .FBET2 = -1.0245;
    .LP2 = 9.42e-09;
    .BETW1 = 0.6567;
    .BETW2 = -0.083639;
    .WBET = 1.0063e-10;
    .STBETO = 1.6942;
    .STBETL = -0.0065587;
    .STBETW = -0.060053;
    .STBETLW = 0.00036994;
    .MUEO = 0.85058 * corner_moshv.sg13g2_hv_nmos_mueo;
    .MUEW = -0.018226;
    .STMUEO = 0.34067;
    .THEMUO = 2.5509;
    .STTHEMUO = 0.63756;
    .CSO = 2.0494;
    .CSL = -0.97261;
    .CSLEXP = 0.0;
    .CSW = 0.044205;
    .CSLW = -1.0021;
    .STCSO = 2.5545;
    .THECSO = 2.0;
    .STTHECSO = 0.0;
    .XCORO = 0.04872;
    .XCORL = -0.27137;
    .XCORW = -0.1948;
    .XCORLW = 0.0;
    .STXCORO = 1.1327;
    .FETAO = 1.0706;
    .RSW1 = 407.81 * corner_moshv.sg13g2_hv_nmos_rsw1;
    .RSW2 = -0.07;
    .STRSO = -0.058157;
    .RSBO = -0.0025425;
    .RSGO = 0.10986 * corner_moshv.sg13g2_hv_nmos_rsgo;
    .THESATO = 0.1 * corner_moshv.sg13g2_hv_nmos_thesato;
    .THESATL = 0.4314 * corner_moshv.sg13g2_hv_nmos_thesatl;
    .THESATLEXP = 1.0973;
    .THESATW = 0.082797 * corner_moshv.sg13g2_hv_nmos_thesatw;
    .THESATLW = -0.020497 * corner_moshv.sg13g2_hv_nmos_thesatlw;
    .STTHESATO = 0.48396;
    .STTHESATL = 0.50226;
    .STTHESATW = 0.049985;
    .STTHESATLW = -0.059487;
    .THESATBO = 0.06;
    .THESATGO = 0.050814;
    .AXO = 8.7694;
    .AXL = 2.3029;
    .ALPL = 0.0019702;
    .ALPLEXP = 1.4003;
    .ALPW = 1.1052;
    .ALP1L1 = 0.007475;
    .ALP1LEXP = 0.80983;
    .ALP1L2 = 0.719;
    .ALP1W = 0.56703;
    .ALP2L1 = 5.413e-07;
    .ALP2LEXP = 0.2541;
    .ALP2L2 = 0.0;
    .ALP2W = -10.0;
    .VPO = 0.06567;
    .A1O = 4.7288;
    .A1L = 0.052459;
    .A1W = 0.024056;
    .A2O = 22.013;
    .STA2O = 0.018532;
    .A3O = 1.2047;
    .A3L = -0.10308;
    .A3W = 0.0069117;
    .A4O = 0.12894;
    .A4L = -0.05413;
    .A4W = -0.06197;
    .GCOO = 0.0;
    .IGINVLW = 0.0 * (1 + 0.0 / l) * (1 + 0.0 / w);
    .IGOVW = 0.0;
    .IGOVDW = 0.0;
    .STIGO = 2.0;
    .GC2O = 0.375;
    .GC3O = 0.063;
    .CHIBO = 3.1;
    .AGIDLW = 70.0;
    .AGIDLDW = 0.0;
    .BGIDLO = 13.0;
    .BGIDLDO = 41.0;
    .STBGIDLO = -0.001067;
    .STBGIDLDO = 0.0;
    .CGIDLO = 0.0;
    .CGIDLDO = 0.0;
    .CGBOVL = 2.522e-16;
    .CFRDW = 0.0;
    .FNTO = 1.0;
    .FNTEXCL = 0.0;
    .NFALW = 1.42e+25;
    .NFBLW = 574300000.0;
    .NFCLW = -3.015e-08;
    .EFO = 1.0;
    .LINTNOI = -3.158e-08;
    .ALPNOI = 2.708;
    .WEDGE = 1e-08;
    .WEDGEW = 0.0;
    .VFBEDGEO = -1.0;
    .STVFBEDGEO = 0.0005;
    .STVFBEDGEL = 0.0;
    .STVFBEDGEW = 0.0;
    .STVFBEDGELW = 0.0;
    .DPHIBEDGEO = 0.0;
    .DPHIBEDGEL = 0.0;
    .DPHIBEDGELEXP = 1.0;
    .DPHIBEDGEW = 0.0;
    .DPHIBEDGELW = 0.0;
    .NSUBEDGEO = 5e+23;
    .NSUBEDGEL = 0.0;
    .NSUBEDGELEXP = 1.0;
    .NSUBEDGEW = 0.0;
    .NSUBEDGELW = 0.0;
    .CTEDGEO = 0.0;
    .CTEDGEL = 0.0;
    .CTEDGELEXP = 1.0;
    .FBETEDGE = 0.0;
    .LPEDGE = 1e-08;
    .BETEDGEW = 0.0;
    .STBETEDGEO = 1.0;
    .STBETEDGEL = 0.0;
    .STBETEDGEW = 0.0;
    .STBETEDGELW = 0.0;
    .PSCEEDGEL = 0.0;
    .PSCEEDGELEXP = 2.0;
    .PSCEEDGEW = 0.0;
    .PSCEBEDGEO = 0.0;
    .PSCEDEDGEO = 0.0;
    .CFEDGEL = 0.0;
    .CFEDGELEXP = 2.0;
    .CFEDGEW = 0.0;
    .CFDEDGEO = 0.0;
    .CFBEDGEO = 0.0;
    .FNTEDGEO = 1.0;
    .NFAEDGELW = 8e+22;
    .NFBEDGELW = 30000000.0;
    .NFCEDGELW = 0.0;
    .EFEDGEO = 1.0;
    .SAREF = 1e-06;
    .SBREF = 1e-06;
    .WLOD = 0.0;
    .KUO = 0.0;
    .KVSAT = 0.0;
    .TKUO = 0.0;
    .LKUO = 0.0;
    .WKUO = 0.0;
    .PKUO = 0.0;
    .LLODKUO = 0.0;
    .WLODKUO = 0.0;
    .KVTHO = 0.0;
    .LKVTHO = 0.0;
    .WKVTHO = 0.0;
    .PKVTHO = 0.0;
    .LLODVTH = 0.0;
    .WLODVTH = 0.0;
    .STETAO = 0.0;
    .LODETAO = 1.0;
    .SCREF = 1e-06;
    .WEB = 0.0;
    .WEC = 0.0;
    .KVTHOWEO = 0.0;
    .KVTHOWEL = 0.0;
    .KVTHOWEW = 0.0;
    .KVTHOWELW = 0.0;
    .KUOWEO = 0.0;
    .KUOWEL = 0.0;
    .KUOWEW = 0.0;
    .KUOWELW = 0.0;
    .TRJ = 21.0;
    .SWJUNEXP = 0.0;
    .IMAX = 0.0020128;
    .FREV = 1000.0;
    .CJORBOT = 0.00085856 * corner_moshv.sg13g2_hv_nmos_cjorbot;
    .CJORSTI = 2.4557e-11 * corner_moshv.sg13g2_hv_nmos_cjorsti;
    .CJORGAT = 1.3846e-11 * corner_moshv.sg13g2_hv_nmos_cjorgat;
    .VBIRBOT = 0.74373;
    .VBIRSTI = 1.597;
    .VBIRGAT = 0.6629;
    .PBOT = 0.27424;
    .PSTI = 0.16571;
    .PGAT = 0.1451;
    .CJORBOTD = 0.001;
    .CJORSTID = 1e-09;
    .CJORGATD = 1e-09;
    .VBIRBOTD = 1.0;
    .VBIRSTID = 1.0;
    .VBIRGATD = 1.0;
    .PBOTD = 0.5;
    .PSTID = 0.5;
    .PGATD = 0.5;
    .PHIGBOT = 1.1984;
    .PHIGSTI = 1.006;
    .PHIGGAT = 0.3;
    .IDSATRBOT = 5.397e-08;
    .IDSATRSTI = 4.0612e-15;
    .IDSATRGAT = 0.0;
    .CSRHBOT = 100.0;
    .CSRHSTI = 0.0001;
    .CSRHGAT = 0.0001;
    .XJUNSTI = 1.61e-08;
    .XJUNGAT = 6.134e-07;
    .PHIGBOTD = 1.16;
    .PHIGSTID = 1.16;
    .PHIGGATD = 1.16;
    .IDSATRBOTD = 1e-12;
    .IDSATRSTID = 1e-18;
    .IDSATRGATD = 1e-18;
    .CSRHBOTD = 100.0;
    .CSRHSTID = 0.0001;
    .CSRHGATD = 0.0001;
    .XJUNSTID = 1e-07;
    .XJUNGATD = 1e-07;
    .CTATBOT = 100.0;
    .CTATSTI = 0.0001;
    .CTATGAT = 0.0001;
    .MEFFTATBOT = 0.25;
    .MEFFTATSTI = 0.25;
    .MEFFTATGAT = 0.25;
    .CTATBOTD = 100.0;
    .CTATSTID = 0.0001;
    .CTATGATD = 0.0001;
    .MEFFTATBOTD = 0.25;
    .MEFFTATSTID = 0.25;
    .MEFFTATGATD = 0.25;
    .CBBTBOT = 1e-12;
    .CBBTSTI = 1e-21;
    .CBBTGAT = 1e-18;
    .FBBTRBOT = 1000000000.0;
    .FBBTRSTI = 1000000000.0;
    .FBBTRGAT = 1000000000.0;
    .STFBBTBOT = -0.001;
    .STFBBTSTI = -0.001;
    .STFBBTGAT = -0.001;
    .CBBTBOTD = 1e-12;
    .CBBTSTID = 1e-18;
    .CBBTGATD = 1e-18;
    .FBBTRBOTD = 1000000000.0;
    .FBBTRSTID = 1000000000.0;
    .FBBTRGATD = 1000000000.0;
    .STFBBTBOTD = -0.001;
    .STFBBTSTID = -0.001;
    .STFBBTGATD = -0.001;
    .VBRBOT = 10.0;
    .VBRSTI = 10.0;
    .VBRGAT = 10.0;
    .PBRBOT = 4.0;
    .PBRSTI = 4.0;
    .PBRGAT = 4.0;
    .VBRBOTD = 10.0;
    .VBRSTID = 10.0;
    .VBRGATD = 10.0;
    .PBRBOTD = 4.0;
    .PBRSTID = 4.0;
    .PBRGATD = 4.0;
    .VJUNREF = 2.5;
    .FJUNQ = 0.03;
    .VJUNREFD = 2.5;
    .FJUNQD = 0.03;
    .RINT = 3.0856e-12;
    .RVPOLY = 0.0;
    .DLSIL = 0.0;
    .RSH = 0.0;
    .RSHD = 0.0;
    .CFRW = pre_layout * 1.2e-16/ng;
    .RSHG = 20.0;
    .RGO = 35.0;
    .RBULKO = 0.002 * ng / w;
    .RWELLO = 0.002 * ng / w;
    .RJUNSO = 5000.0 * l / w;
    .RJUNDO = 5000.0 * l / w;
    .SWSOA = swsoa;
    .VGS_MAX = 3.0;
    .VGD_MAX = 3.0;
    .VGB_MAX = 3.0;
    .VDS_MAX = 3.0;
    .VDB_MAX = 1.6;
    .VSB_MAX = 1.6;
endparamset

//Generated from SPICE model card sg13g2_hv_pmos_psp in sg13g2_moshv_parm.lib
paramset sg13g2_hv_pmos_psp PSP103VA
   parameter integer rfmode = 0 from [0:0];
   parameter real w = 0.35u;
   parameter real l = 0.40u;
   parameter integer ng = 1;
   parameter real mult = 1.0;
   parameter real as = 0.0;
   parameter real ad = 0.0;
   parameter real ps = 0.0;
   parameter real pd = 0.0;
   parameter real dta = 0.0;
   parameter real ngcon = 1.0;
   parameter real delvto = 0.0;
   parameter real factuo = 1.0;
   parameter real pre_layout = 1.0;
   parameter real swsoa = 0.0;
    .LEVEL = 103.8.2;
    .TYPE = -1;
    .W = w;
    .L = l;
    .NF = ng;
    .MULT = mult;
    .AS = as;
    .AD = ad;
    .PS = ps;
    .PD = pd;
    .TR = 27.0;
    .DTA = dta;
    .NGCON = ngcon;
    .DELVTO = delvto;
    .FACTUO = factuo;
    .SWGEO = 1.0;
    .SWIGATE = 1.0;
    .SWIMPACT = 1.0;
    .SWGIDL = 1.0;
    .SWJUNCAP = 3.0;
    .SWJUNASYM = 0.0;
    .SWNUD = 0.0;
    .SWEDGE = 0.0;
    .SWDELVTAC = 0.0;
    .SWIGN = 1.0;
    .QMC = 1.0;
    .LVARO = -1.735e-09;
    .LVARL = 0.0;
    .LVARW = 0.0;
    .LAP = 3.471e-08;
    .WVARO = 0.0;
    .WVARL = 0.0;
    .WVARW = 0.0;
    .WOT = 0.0;
    .DLQ = 3.537e-08 - ((1 - pre_layout) * 1e-07);
    .DWQ = 3e-08;
    .VFBO = -1.0717 * corner_moshv.sg13g2_hv_pmos_vfbo;
    .VFBL = -0.03;
    .VFBW = 0.0;
    .VFBLW = 0.0;
    .STVFBO = 0.00057379;
    .STVFBL = 8.6794e-05;
    .STVFBW = 4.9309e-05;
    .STVFBLW = -3.6436e-05;
    .ST2VFBO = 0.0;
    .TOXO = 6.945e-09 * corner_moshv.sg13g2_hv_pmos_toxo;
    .EPSROXO = 3.9;
    .NSUBO = 4.2268e+23;
    .NSUBW = 0.01112;
    .WSEG = 5.362e-08;
    .NPCK = 8.0711e+23;
    .NPCKW = -0.011403;
    .WSEGP = 1e-06;
    .LPCK = 8.3733e-09;
    .LPCKW = 0.077499;
    .FOL1 = 0.065253;
    .FOL2 = 0.010199;
    .FACNEFFACO = 1.0;
    .FACNEFFACL = 0.0;
    .FACNEFFACW = 0.0;
    .FACNEFFACLW = 0.0;
    .GFACNUDO = 1.0;
    .GFACNUDL = 0.0;
    .GFACNUDLEXP = 1.0;
    .GFACNUDW = 0.0;
    .GFACNUDLW = 0.0;
    .VSBNUDO = 0.0;
    .DVSBNUDO = 1.0;
    .VNSUBO = 0.0;
    .NSLPO = 0.05;
    .DNSUBO = 0.03585;
    .DPHIBO = -0.077807 * corner_moshv.sg13g2_hv_pmos_dphibo;
    .DPHIBL = 0.0055386 * corner_moshv.sg13g2_hv_pmos_dphibl;
    .DPHIBLEXP = 2.1893;
    .DPHIBW = -0.007913 * corner_moshv.sg13g2_hv_pmos_dphibw;
    .DPHIBLW = 0.00055473 * corner_moshv.sg13g2_hv_pmos_dphiblw;
    .DELVTACO = 0.0;
    .DELVTACL = 0.0;
    .DELVTACLEXP = 1.0;
    .DELVTACW = 0.0;
    .DELVTACLW = 0.0;
    .NPO = 1.092e+26;
    .NPL = 0.2188;
    .TOXOVO = 6.945e-09 * corner_moshv.sg13g2_hv_pmos_toxovo;
    .TOXOVDO = 2e-09;
    .LOV = 3.471e-08 - ((1 - pre_layout) * 2.4e-08);
    .LOVD = 0.0;
    .NOVO = 1.99e+26;
    .NOVDO = 5e+25;
    .CTO = -0.006328;
    .CTL = 0.0;
    .CTLEXP = 1.0;
    .CTW = 0.3006;
    .CTLW = -0.01196;
    .CTGO = 0.0;
    .CTBO = 0.0;
    .STCTO = 1.0;
    .CFL = 0.00045884;
    .CFLEXP = 2.2055;
    .CFW = 0.45909;
    .CFBO = 1.0;
    .CFDO = 0.0;
    .PSCEL = 0.0;
    .PSCELEXP = 2.0;
    .PSCEW = 0.0;
    .PSCEBO = 0.0;
    .PSCEDO = 0.0;
    .UO = 0.018428;
    .FBET1 = 0.15952;
    .FBET1W = -2.1872;
    .LP1 = 9.9822e-08;
    .LP1W = -1.0871;
    .FBET2 = -2.7066;
    .LP2 = 5.8401e-08;
    .BETW1 = -0.097534;
    .BETW2 = 0.022314;
    .WBET = 7.9844e-10;
    .STBETO = 1.6489;
    .STBETL = 0.029528;
    .STBETW = 0.037078;
    .STBETLW = 0.046991;
    .MUEO = 1.8162 * corner_moshv.sg13g2_hv_pmos_mueo;
    .MUEW = -0.06367;
    .STMUEO = 1.0816;
    .THEMUO = 1.0324;
    .STTHEMUO = 0.26337;
    .CSO = 0.18648;
    .CSL = 0.21903 * corner_moshv.sg13g2_hv_pmos_csl;
    .CSLEXP = 2.0917;
    .CSW = 0.0072837;
    .CSLW = 0.02;
    .STCSO = 2.0;
    .THECSO = 2.0;
    .STTHECSO = 0.0;
    .XCORO = 0.001363;
    .XCORL = 8.0;
    .XCORW = 0.0060537;
    .XCORLW = 0.058951;
    .STXCORO = -6.939e-18;
    .FETAO = 1.2853;
    .RSW1 = 1970.0 * corner_moshv.sg13g2_hv_pmos_rsw1;
    .RSW2 = -0.057547;
    .STRSO = -0.24812;
    .RSBO = 0.074639;
    .RSGO = 0.21144 * corner_moshv.sg13g2_hv_pmos_rsgo;
    .THESATO = 8.4917e-05 * corner_moshv.sg13g2_hv_pmos_thesato;
    .THESATL = 0.014 * corner_moshv.sg13g2_hv_pmos_thesatl;
    .THESATLEXP = 2.395;
    .THESATW = 0.2 * corner_moshv.sg13g2_hv_pmos_thesatw;
    .THESATLW = -0.01 * corner_moshv.sg13g2_hv_pmos_thesatlw;
    .STTHESATO = 3.0405;
    .STTHESATL = -0.16001;
    .STTHESATW = -0.96988;
    .STTHESATLW = 0.36213;
    .THESATBO = 0.1;
    .THESATGO = 0.6304;
    .AXO = 16.822;
    .AXL = 3.0092;
    .ALPL = 0.0058454;
    .ALPLEXP = 0.47562;
    .ALPW = -0.065973;
    .ALP1L1 = 4.4409e-16;
    .ALP1LEXP = 1.347;
    .ALP1L2 = 1.0;
    .ALP1W = 2.0;
    .ALP2L1 = 3.6779e-06;
    .ALP2LEXP = 0.2531;
    .ALP2L2 = 2.2204e-15;
    .ALP2W = 0.9582;
    .VPO = 1.8436e-06;
    .A1O = 47.788;
    .A1L = 0.029145;
    .A1W = 0.01435;
    .A2O = 38.581;
    .STA2O = -0.0049931;
    .A3O = 1.1753;
    .A3L = -0.069795;
    .A3W = 0.0032538;
    .A4O = 0.12593;
    .A4L = -0.07;
    .A4W = -0.04811;
    .GCOO = 0.0;
    .IGINVLW = 0.0 * (1 + 0.0 / l) * (1 + 0.0 / w);
    .IGOVW = 0.0;
    .IGOVDW = 0.0;
    .STIGO = 2.0;
    .GC2O = 0.375;
    .GC3O = 0.063;
    .CHIBO = 3.1;
    .AGIDLW = 6e-10;
    .AGIDLDW = 0.0;
    .BGIDLO = 6.656 * corner_moshv.sg13g2_hv_pmos_bgidlo;
    .BGIDLDO = 41.0;
    .STBGIDLO = -0.0049461;
    .STBGIDLDO = 0.0;
    .CGIDLO = 0.23693;
    .CGIDLDO = 0.0;
    .CGBOVL = -4.669e-16;
    .CFRDW = 0.0;
    .FNTO = 1.0;
    .FNTEXCL = 0.0;
    .NFALW = 1.3e+25;
    .NFBLW = 5289000000.0;
    .NFCLW = 2e-07;
    .EFO = 1.152;
    .LINTNOI = 2.5e-08;
    .ALPNOI = 2.0;
    .WEDGE = 1e-08;
    .WEDGEW = 0.0;
    .VFBEDGEO = -1.0;
    .STVFBEDGEO = 0.0005;
    .STVFBEDGEL = 0.0;
    .STVFBEDGEW = 0.0;
    .STVFBEDGELW = 0.0;
    .DPHIBEDGEO = 0.0;
    .DPHIBEDGEL = 0.0;
    .DPHIBEDGELEXP = 1.0;
    .DPHIBEDGEW = 0.0;
    .DPHIBEDGELW = 0.0;
    .NSUBEDGEO = 5e+23;
    .NSUBEDGEL = 0.0;
    .NSUBEDGELEXP = 1.0;
    .NSUBEDGEW = 0.0;
    .NSUBEDGELW = 0.0;
    .CTEDGEO = 0.0;
    .CTEDGEL = 0.0;
    .CTEDGELEXP = 1.0;
    .FBETEDGE = 0.0;
    .LPEDGE = 1e-08;
    .BETEDGEW = 0.0;
    .STBETEDGEO = 1.0;
    .STBETEDGEL = 0.0;
    .STBETEDGEW = 0.0;
    .STBETEDGELW = 0.0;
    .PSCEEDGEL = 0.0;
    .PSCEEDGELEXP = 2.0;
    .PSCEEDGEW = 0.0;
    .PSCEBEDGEO = 0.0;
    .PSCEDEDGEO = 0.0;
    .CFEDGEL = 0.0;
    .CFEDGELEXP = 2.0;
    .CFEDGEW = 0.0;
    .CFDEDGEO = 0.0;
    .CFBEDGEO = 0.0;
    .FNTEDGEO = 1.0;
    .NFAEDGELW = 8e+22;
    .NFBEDGELW = 30000000.0;
    .NFCEDGELW = 0.0;
    .EFEDGEO = 1.0;
    .SAREF = 1e-06;
    .SBREF = 1e-06;
    .WLOD = 0.0;
    .KUO = 0.0;
    .KVSAT = 0.0;
    .TKUO = 0.0;
    .LKUO = 0.0;
    .WKUO = 0.0;
    .PKUO = 0.0;
    .LLODKUO = 0.0;
    .WLODKUO = 0.0;
    .KVTHO = 0.0;
    .LKVTHO = 0.0;
    .WKVTHO = 0.0;
    .PKVTHO = 0.0;
    .LLODVTH = 0.0;
    .WLODVTH = 0.0;
    .STETAO = 0.0;
    .LODETAO = 1.0;
    .SCREF = 1e-06;
    .WEB = 0.0;
    .WEC = 0.0;
    .KVTHOWEO = 0.0;
    .KVTHOWEL = 0.0;
    .KVTHOWEW = 0.0;
    .KVTHOWELW = 0.0;
    .KUOWEO = 0.0;
    .KUOWEL = 0.0;
    .KUOWEW = 0.0;
    .KUOWELW = 0.0;
    .TRJ = 21.0;
    .SWJUNEXP = 0.0;
    .IMAX = 0.0024527;
    .FREV = 1000.0;
    .CJORBOT = 0.0008095 * corner_moshv.sg13g2_hv_pmos_cjorbot;
    .CJORSTI = 4.2583e-11 * corner_moshv.sg13g2_hv_pmos_cjorsti;
    .CJORGAT = 3.1e-11 * corner_moshv.sg13g2_hv_pmos_cjorgat;
    .VBIRBOT = 0.72606;
    .VBIRSTI = 0.69819;
    .VBIRGAT = 1.199;
    .PBOT = 0.33078;
    .PSTI = 0.22409;
    .PGAT = 0.4474;
    .CJORBOTD = 0.001;
    .CJORSTID = 1e-09;
    .CJORGATD = 1e-09;
    .VBIRBOTD = 1.0;
    .VBIRSTID = 1.0;
    .VBIRGATD = 1.0;
    .PBOTD = 0.5;
    .PSTID = 0.5;
    .PGATD = 0.5;
    .PHIGBOT = 1.0641;
    .PHIGSTI = 1.3946;
    .PHIGGAT = 1.83;
    .IDSATRBOT = 3.0606e-08;
    .IDSATRSTI = 3.6127e-15;
    .IDSATRGAT = 0.0;
    .CSRHBOT = 100.0;
    .CSRHSTI = 0.0001;
    .CSRHGAT = 0.0001;
    .XJUNSTI = 4.93e-08;
    .XJUNGAT = 7.062e-07;
    .PHIGBOTD = 1.16;
    .PHIGSTID = 1.16;
    .PHIGGATD = 1.16;
    .IDSATRBOTD = 1e-12;
    .IDSATRSTID = 1e-18;
    .IDSATRGATD = 1e-18;
    .CSRHBOTD = 100.0;
    .CSRHSTID = 0.0001;
    .CSRHGATD = 0.0001;
    .XJUNSTID = 1e-07;
    .XJUNGATD = 1e-07;
    .CTATBOT = 100.0;
    .CTATSTI = 0.0001;
    .CTATGAT = 0.0001;
    .MEFFTATBOT = 0.25;
    .MEFFTATSTI = 0.25;
    .MEFFTATGAT = 0.25;
    .CTATBOTD = 100.0;
    .CTATSTID = 0.0001;
    .CTATGATD = 0.0001;
    .MEFFTATBOTD = 0.25;
    .MEFFTATSTID = 0.25;
    .MEFFTATGATD = 0.25;
    .CBBTBOT = 1e-12;
    .CBBTSTI = 1e-21;
    .CBBTGAT = 1e-18;
    .FBBTRBOT = 1000000000.0;
    .FBBTRSTI = 1000000000.0;
    .FBBTRGAT = 1000000000.0;
    .STFBBTBOT = -0.001;
    .STFBBTSTI = -0.001;
    .STFBBTGAT = -0.001;
    .CBBTBOTD = 1e-12;
    .CBBTSTID = 1e-18;
    .CBBTGATD = 1e-18;
    .FBBTRBOTD = 1000000000.0;
    .FBBTRSTID = 1000000000.0;
    .FBBTRGATD = 1000000000.0;
    .STFBBTBOTD = -0.001;
    .STFBBTSTID = -0.001;
    .STFBBTGATD = -0.001;
    .VBRBOT = 10.0;
    .VBRSTI = 10.0;
    .VBRGAT = 10.0;
    .PBRBOT = 4.0;
    .PBRSTI = 4.0;
    .PBRGAT = 4.0;
    .VBRBOTD = 10.0;
    .VBRSTID = 10.0;
    .VBRGATD = 10.0;
    .PBRBOTD = 4.0;
    .PBRSTID = 4.0;
    .PBRGATD = 4.0;
    .VJUNREF = 2.5;
    .FJUNQ = 0.03;
    .VJUNREFD = 2.5;
    .FJUNQD = 0.03;
    .RINT = 0.0;
    .RVPOLY = 0.0;
    .DLSIL = 0.0;
    .RSH = 0.0;
    .RSHD = 0.0;
    .CFRW = pre_layout * 0.0 / ng;
    .RSHG = 40.0;
    .RGO = 15.0;
    .RBULKO = 0.002 * ng / w;
    .RWELLO = 0.001 * ng / w;
    .RJUNSO = 5000.0 * l / w;
    .RJUNDO = 5000.0 * l / w;
    .SWSOA = swsoa;
    .VGS_MAX = 3.0;
    .VGD_MAX = 3.0;
    .VGB_MAX = 3.0;
    .VDS_MAX = 3.0;
    .VDB_MAX = 1.6;
    .VSB_MAX = 1.6;
endparamset
