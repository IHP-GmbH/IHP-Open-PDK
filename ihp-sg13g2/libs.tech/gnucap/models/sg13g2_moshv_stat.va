`include "disciplines.vams"

`define sg13g2_hv_nmos_vfbo_mm (((0.004 <= 0) || (`mc_ok <= 0) ? `sg13g2_hv_nmos_vfbo_mm_norm : $rdist_normal(_rdist_seed, `sg13g2_hv_nmos_vfbo_mm_norm, (0.004 * `sg13g2_hv_nmos_vfbo_mm_norm) / `mc_ok)))
`define sg13g2_hv_nmos_rsgo (((1e-9 <= 0) || (`mc_ok <= 0) ? `sg13g2_hv_nmos_rsgo_norm : $rdist_normal(_rdist_seed, `sg13g2_hv_nmos_rsgo_norm, (1e-9 * `sg13g2_hv_nmos_rsgo_norm) / `mc_ok)))
`define sg13g2_hv_nmos_rsw1 (((0.0001 <= 0) || (`mc_ok <= 0) ? `sg13g2_hv_nmos_rsw1_norm : $rdist_normal(_rdist_seed, `sg13g2_hv_nmos_rsw1_norm, (0.0001 * `sg13g2_hv_nmos_rsw1_norm) / `mc_ok)))
`define sg13g2_hv_nmos_mueo (((0.0335 <= 0) || (`mc_ok <= 0) ? `sg13g2_hv_nmos_mueo_norm : $rdist_normal(_rdist_seed, `sg13g2_hv_nmos_mueo_norm, (0.0335 * `sg13g2_hv_nmos_mueo_norm) / `mc_ok)))
`define sg13g2_hv_nmos_dphibo (((0.1503 <= 0) || (`mc_ok <= 0) ? `sg13g2_hv_nmos_dphibo_norm : $rdist_normal(_rdist_seed, `sg13g2_hv_nmos_dphibo_norm, (0.1503 * `sg13g2_hv_nmos_dphibo_norm) / `mc_ok)))
`define sg13g2_hv_nmos_dphibl (((0.2052 <= 0) || (`mc_ok <= 0) ? `sg13g2_hv_nmos_dphibl_norm : $rdist_normal(_rdist_seed, `sg13g2_hv_nmos_dphibl_norm, (0.2052 * `sg13g2_hv_nmos_dphibl_norm) / `mc_ok)))
`define sg13g2_hv_nmos_dphibw (((1e-9 <= 0) || (`mc_ok <= 0) ? `sg13g2_hv_nmos_dphibw_norm : $rdist_normal(_rdist_seed, `sg13g2_hv_nmos_dphibw_norm, (1e-9 * `sg13g2_hv_nmos_dphibw_norm) / `mc_ok)))
`define sg13g2_hv_nmos_dphiblw (((0.0151 <= 0) || (`mc_ok <= 0) ? `sg13g2_hv_nmos_dphiblw_norm : $rdist_normal(_rdist_seed, `sg13g2_hv_nmos_dphiblw_norm, (0.0151 * `sg13g2_hv_nmos_dphiblw_norm) / `mc_ok)))
`define sg13g2_hv_nmos_ctl (((1e-9 <= 0) || (`mc_ok <= 0) ? `sg13g2_hv_nmos_ctl_norm : $rdist_normal(_rdist_seed, `sg13g2_hv_nmos_ctl_norm, (1e-9 * `sg13g2_hv_nmos_ctl_norm) / `mc_ok)))
`define sg13g2_hv_nmos_thesato (((1e-9 <= 0) || (`mc_ok <= 0) ? `sg13g2_hv_nmos_thesato_norm : $rdist_normal(_rdist_seed, `sg13g2_hv_nmos_thesato_norm, (1e-9 * `sg13g2_hv_nmos_thesato_norm) / `mc_ok)))
`define sg13g2_hv_nmos_thesatl (((0.0358 <= 0) || (`mc_ok <= 0) ? `sg13g2_hv_nmos_thesatl_norm : $rdist_normal(_rdist_seed, `sg13g2_hv_nmos_thesatl_norm, (0.0358 * `sg13g2_hv_nmos_thesatl_norm) / `mc_ok)))
`define sg13g2_hv_nmos_thesatw (((1e-9 <= 0) || (`mc_ok <= 0) ? `sg13g2_hv_nmos_thesatw_norm : $rdist_normal(_rdist_seed, `sg13g2_hv_nmos_thesatw_norm, (1e-9 * `sg13g2_hv_nmos_thesatw_norm) / `mc_ok)))
`define sg13g2_hv_nmos_thesatlw (((0.0353 <= 0) || (`mc_ok <= 0) ? `sg13g2_hv_nmos_thesatlw_norm : $rdist_normal(_rdist_seed, `sg13g2_hv_nmos_thesatlw_norm, (0.0353 * `sg13g2_hv_nmos_thesatlw_norm) / `mc_ok)))
`define sg13g2_hv_nmos_toxo (((0.0133 <= 0) || (`mc_ok <= 0) ? `sg13g2_hv_nmos_toxo_norm : $rdist_normal(_rdist_seed, `sg13g2_hv_nmos_toxo_norm, (0.0133 * `sg13g2_hv_nmos_toxo_norm) / `mc_ok)))
`define sg13g2_hv_nmos_toxovo (((0.0133 <= 0) || (`mc_ok <= 0) ? `sg13g2_hv_nmos_toxovo_norm : $rdist_normal(_rdist_seed, `sg13g2_hv_nmos_toxovo_norm, (0.0133 * `sg13g2_hv_nmos_toxovo_norm) / `mc_ok)))
`define sg13g2_hv_nmos_cjorbot (((0.0267 <= 0) || (`mc_ok <= 0) ? `sg13g2_hv_nmos_cjorbot_norm : $rdist_normal(_rdist_seed, `sg13g2_hv_nmos_cjorbot_norm, (0.0267 * `sg13g2_hv_nmos_cjorbot_norm) / `mc_ok)))
`define sg13g2_hv_nmos_cjorsti (((0.0267 <= 0) || (`mc_ok <= 0) ? `sg13g2_hv_nmos_cjorsti_norm : $rdist_normal(_rdist_seed, `sg13g2_hv_nmos_cjorsti_norm, (0.0267 * `sg13g2_hv_nmos_cjorsti_norm) / `mc_ok)))
`define sg13g2_hv_nmos_cjorgat (((0.0267 <= 0) || (`mc_ok <= 0) ? `sg13g2_hv_nmos_cjorgat_norm : $rdist_normal(_rdist_seed, `sg13g2_hv_nmos_cjorgat_norm, (0.0267 * `sg13g2_hv_nmos_cjorgat_norm) / `mc_ok)))
`define sg13g2_hv_pmos_vfbo_mm (((0.004 <= 0) || (`mc_ok <= 0) ? `sg13g2_hv_pmos_vfbo_mm_norm : $rdist_normal(_rdist_seed, `sg13g2_hv_pmos_vfbo_mm_norm, (0.004 * `sg13g2_hv_pmos_vfbo_mm_norm) / `mc_ok)))
`define sg13g2_hv_pmos_rsgo (((0.4253 <= 0) || (`mc_ok <= 0) ? `sg13g2_hv_pmos_rsgo_norm : $rdist_normal(_rdist_seed, `sg13g2_hv_pmos_rsgo_norm, (0.4253 * `sg13g2_hv_pmos_rsgo_norm) / `mc_ok)))
`define sg13g2_hv_pmos_rsw1 (((1e-9 <= 0) || (`mc_ok <= 0) ? `sg13g2_hv_pmos_rsw1_norm : $rdist_normal(_rdist_seed, `sg13g2_hv_pmos_rsw1_norm, (1e-9 * `sg13g2_hv_pmos_rsw1_norm) / `mc_ok)))
`define sg13g2_hv_pmos_mueo (((0.0014 <= 0) || (`mc_ok <= 0) ? `sg13g2_hv_pmos_mueo_norm : $rdist_normal(_rdist_seed, `sg13g2_hv_pmos_mueo_norm, (0.0014 * `sg13g2_hv_pmos_mueo_norm) / `mc_ok)))
`define sg13g2_hv_pmos_dphibo (((0.0572 <= 0) || (`mc_ok <= 0) ? `sg13g2_hv_pmos_dphibo_norm : $rdist_normal(_rdist_seed, `sg13g2_hv_pmos_dphibo_norm, (0.0572 * `sg13g2_hv_pmos_dphibo_norm) / `mc_ok)))
`define sg13g2_hv_pmos_dphibl (((0.0672 <= 0) || (`mc_ok <= 0) ? `sg13g2_hv_pmos_dphibl_norm : $rdist_normal(_rdist_seed, `sg13g2_hv_pmos_dphibl_norm, (0.0672 * `sg13g2_hv_pmos_dphibl_norm) / `mc_ok)))
`define sg13g2_hv_pmos_dphibw (((0.0183 <= 0) || (`mc_ok <= 0) ? `sg13g2_hv_pmos_dphibw_norm : $rdist_normal(_rdist_seed, `sg13g2_hv_pmos_dphibw_norm, (0.0183 * `sg13g2_hv_pmos_dphibw_norm) / `mc_ok)))
`define sg13g2_hv_pmos_dphiblw (((1.0138 <= 0) || (`mc_ok <= 0) ? `sg13g2_hv_pmos_dphiblw_norm : $rdist_normal(_rdist_seed, `sg13g2_hv_pmos_dphiblw_norm, (1.0138 * `sg13g2_hv_pmos_dphiblw_norm) / `mc_ok)))
`define sg13g2_hv_pmos_bgidlo (((0.1538 <= 0) || (`mc_ok <= 0) ? `sg13g2_hv_pmos_bgidlo_norm : $rdist_normal(_rdist_seed, `sg13g2_hv_pmos_bgidlo_norm, (0.1538 * `sg13g2_hv_pmos_bgidlo_norm) / `mc_ok)))
`define sg13g2_hv_pmos_thesato (((1e-9 <= 0) || (`mc_ok <= 0) ? `sg13g2_hv_pmos_thesato_norm : $rdist_normal(_rdist_seed, `sg13g2_hv_pmos_thesato_norm, (1e-9 * `sg13g2_hv_pmos_thesato_norm) / `mc_ok)))
`define sg13g2_hv_pmos_thesatl (((0.0198 <= 0) || (`mc_ok <= 0) ? `sg13g2_hv_pmos_thesatl_norm : $rdist_normal(_rdist_seed, `sg13g2_hv_pmos_thesatl_norm, (0.0198 * `sg13g2_hv_pmos_thesatl_norm) / `mc_ok)))
`define sg13g2_hv_pmos_thesatw (((0.4367 <= 0) || (`mc_ok <= 0) ? `sg13g2_hv_pmos_thesatw_norm : $rdist_normal(_rdist_seed, `sg13g2_hv_pmos_thesatw_norm, (0.4367 * `sg13g2_hv_pmos_thesatw_norm) / `mc_ok)))
`define sg13g2_hv_pmos_thesatlw (((1e-9 <= 0) || (`mc_ok <= 0) ? `sg13g2_hv_pmos_thesatlw_norm : $rdist_normal(_rdist_seed, `sg13g2_hv_pmos_thesatlw_norm, (1e-9 * `sg13g2_hv_pmos_thesatlw_norm) / `mc_ok)))
`define sg13g2_hv_pmos_csl (((1e-9 <= 0) || (`mc_ok <= 0) ? `sg13g2_hv_pmos_csl_norm : $rdist_normal(_rdist_seed, `sg13g2_hv_pmos_csl_norm, (1e-9 * `sg13g2_hv_pmos_csl_norm) / `mc_ok)))
`define sg13g2_hv_pmos_toxo (((0.0133 <= 0) || (`mc_ok <= 0) ? `sg13g2_hv_pmos_toxo_norm : $rdist_normal(_rdist_seed, `sg13g2_hv_pmos_toxo_norm, (0.0133 * `sg13g2_hv_pmos_toxo_norm) / `mc_ok)))
`define sg13g2_hv_pmos_toxovo (((0.0133 <= 0) || (`mc_ok <= 0) ? `sg13g2_hv_pmos_toxovo_norm : $rdist_normal(_rdist_seed, `sg13g2_hv_pmos_toxovo_norm, (0.0133 * `sg13g2_hv_pmos_toxovo_norm) / `mc_ok)))
`define sg13g2_hv_pmos_cjorbot (((0.0267 <= 0) || (`mc_ok <= 0) ? `sg13g2_hv_pmos_cjorbot_norm : $rdist_normal(_rdist_seed, `sg13g2_hv_pmos_cjorbot_norm, (0.0267 * `sg13g2_hv_pmos_cjorbot_norm) / `mc_ok)))
`define sg13g2_hv_pmos_cjorsti (((0.0267 <= 0) || (`mc_ok <= 0) ? `sg13g2_hv_pmos_cjorsti_norm : $rdist_normal(_rdist_seed, `sg13g2_hv_pmos_cjorsti_norm, (0.0267 * `sg13g2_hv_pmos_cjorsti_norm) / `mc_ok)))
`define sg13g2_hv_pmos_cjorgat (((0.0267 <= 0) || (`mc_ok <= 0) ? `sg13g2_hv_pmos_cjorgat_norm : $rdist_normal(_rdist_seed, `sg13g2_hv_pmos_cjorgat_norm, (0.0267 * `sg13g2_hv_pmos_cjorgat_norm) / `mc_ok)))
