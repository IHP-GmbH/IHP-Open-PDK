`include "disciplines.vams"

`define sg13g2_hv_nmos_vfbo (`sg13g2_hv_nmos_vfbo_mm_norm)
`define sg13g2_hv_nmos_rsgo (`sg13g2_hv_nmos_rsgo_norm)
`define sg13g2_hv_nmos_rsw1 (`sg13g2_hv_nmos_rsw1_norm)
`define sg13g2_hv_nmos_mueo (`sg13g2_hv_nmos_mueo_norm)
`define sg13g2_hv_nmos_dphibo (`sg13g2_hv_nmos_dphibo_norm)
`define sg13g2_hv_nmos_dphibl (`sg13g2_hv_nmos_dphibl_norm)
`define sg13g2_hv_nmos_dphibw (`sg13g2_hv_nmos_dphibw_norm)
`define sg13g2_hv_nmos_dphiblw (`sg13g2_hv_nmos_dphiblw_norm)
`define sg13g2_hv_nmos_ctl (`sg13g2_hv_nmos_ctl_norm)
`define sg13g2_hv_nmos_thesato (`sg13g2_hv_nmos_thesato_norm)
`define sg13g2_hv_nmos_thesatl (`sg13g2_hv_nmos_thesatl_norm)
`define sg13g2_hv_nmos_thesatw (`sg13g2_hv_nmos_thesatw_norm)
`define sg13g2_hv_nmos_thesatlw (`sg13g2_hv_nmos_thesatlw_norm)
`define sg13g2_hv_nmos_toxo (`sg13g2_hv_nmos_toxo_norm)
`define sg13g2_hv_nmos_toxovo (`sg13g2_hv_nmos_toxovo_norm)
`define sg13g2_hv_nmos_cjorbot (`sg13g2_hv_nmos_cjorbot_norm)
`define sg13g2_hv_nmos_cjorsti (`sg13g2_hv_nmos_cjorsti_norm)
`define sg13g2_hv_nmos_cjorgat (`sg13g2_hv_nmos_cjorgat_norm)
`define sg13g2_hv_pmos_vfbo_mm (`sg13g2_hv_pmos_vfbo_mm_norm)
`define sg13g2_hv_pmos_rsgo (`sg13g2_hv_pmos_rsgo_norm)
`define sg13g2_hv_pmos_rsw1 (`sg13g2_hv_pmos_rsw1_norm)
`define sg13g2_hv_pmos_mueo (`sg13g2_hv_pmos_mueo_norm)
`define sg13g2_hv_pmos_dphibo (`sg13g2_hv_pmos_dphibo_norm)
`define sg13g2_hv_pmos_dphibl (`sg13g2_hv_pmos_dphibl_norm)
`define sg13g2_hv_pmos_dphibw (`sg13g2_hv_pmos_dphibw_norm)
`define sg13g2_hv_pmos_dphiblw (`sg13g2_hv_pmos_dphiblw_norm)
`define sg13g2_hv_pmos_bgidlo (`sg13g2_hv_pmos_bgidlo_norm)
`define sg13g2_hv_pmos_thesato (`sg13g2_hv_pmos_thesato_norm)
`define sg13g2_hv_pmos_thesatl (`sg13g2_hv_pmos_thesatl_norm)
`define sg13g2_hv_pmos_thesatw (`sg13g2_hv_pmos_thesatw_norm)
`define sg13g2_hv_pmos_thesatlw (`sg13g2_hv_pmos_thesatlw_norm)
`define sg13g2_hv_pmos_csl (`sg13g2_hv_pmos_csl_norm)
`define sg13g2_hv_pmos_toxo (`sg13g2_hv_pmos_toxo_norm)
`define sg13g2_hv_pmos_toxovo (`sg13g2_hv_pmos_toxovo_norm)
`define sg13g2_hv_pmos_cjorbot (`sg13g2_hv_pmos_cjorbot_norm)
`define sg13g2_hv_pmos_cjorsti (`sg13g2_hv_pmos_cjorsti_norm)
`define sg13g2_hv_pmos_cjorgat (`sg13g2_hv_pmos_cjorgat_norm)
