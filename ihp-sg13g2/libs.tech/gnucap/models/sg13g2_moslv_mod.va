`include "disciplines.vams"

module sg13_lv_nmos(node_d, node_g, node_s, node_b);
  inout node_d, node_g, node_s, node_b;
  electrical node_d, node_g, node_s, node_b;

  parameter integer _rdist_seed = 0;
  parameter real w = 0.35e-6;
  parameter real l = 0.34e-6;
  parameter real ng = 1;
  parameter real m = 1;
  parameter real as = 0;
  parameter real ad = 0;
  parameter real pd = 0;
  parameter real ps = 0;
  parameter real trise = 0;
  parameter real z1 = 0.34e-6;
  parameter real z2 = 0.38e-6;
  parameter real wmin = 0.15e-6;
  parameter real rfmode = 0;
  parameter real pre_layout = 1;

`include "sg13g2_moslv_parm.va"
  PSPNQS103VA #(
    .SWJUNEXP(0.0),
    .PHIGSTI(1.3844),
    .STETAO(0.0),
    .BETW1(-0.020925),
    .DTA(trise),
    .RSBO(-0.099725),
    .WLODVTH(0.0),
    .LLODVTH(0.0),
    .GFACNUDLW(0.0),
    .WVARO(0.0),
    .THESATO(0.39843),
    .FBBTRBOT(1000000000.0),
    .TOXOVO((2.2404e-09 * `sg13g2_lv_nmos_toxovo)),
    .FBET1(12.168),
    .ALP2LEXP(0.25),
    .STBETEDGELW(0.0),
    .SWIGATE(1.0),
    .VBRBOTD(10.0),
    .FJUNQD(0.03),
    .STFBBTSTI(-0.001),
    .CSW(0.19805),
    .VBRSTI(10.0),
    .UO(0.045582),
    .MUEW((0.030943 * `sg13g2_lv_nmos_muew)),
    .XJUNGATD(1e-07),
    .STVFBW(-1.8689e-05),
    .GC3O(-0.4698),
    .SBREF(1e-06),
    .FNTEXCL(0.0),
    .BETEDGEW(0.0),
    .CFDEDGEO(0.0),
    .SAREF(1e-06),
    .WLODKUO(0.0),
    .STRSO(-0.49693),
    .RWELLO((rfmode * 0.002 * ng / w)),
    .FBBTRSTI(1000000000.0),
    .IGINVLW((121290.0 * (1 + 2.4761e-07 / l) * (1 + -2.1167e-08 / w))),
    .KVSAT(0.0),
    .NFBLW(1026000000.0),
    .PGATD(0.5),
    .DNSUBO(4.4409e-16),
    .ALP2L1(2.6817),
    .STTHEMUO(4.441e-15),
    .THESATW((0.12825 * `sg13g2_lv_nmos_thesatw)),
    .VJUNREF(2.5),
    .MEFFTATGATD(0.25),
    .NF((ng)),
    .PBRSTID(4.0),
    .CTATBOT(100.0),
    .CJORSTI((2.5279e-11 * `sg13g2_lv_nmos_cjorsti)),
    .VBIRSTI(0.79368),
    .FOL1(-0.0091066),
    .CTATBOTD(100.0),
    .LP1(5.1674e-09),
    .KVTHOWEL(0.0),
    .AXL(1.0186),
    .CBBTBOTD(1e-12),
    .NOVDO(5e+25),
    .NSUBEDGEO(5e+23),
    .DVSBNUDO(1.0),
    .CTEDGEO(0.0),
    .DPHIBEDGELW(0.0),
    .CJORGATD(1e-09),
    .DLSIL(0.0),
    .NFCEDGELW(0.0),
    .STVFBLW(5.1435e-07),
    .CSL(0.12341),
    .PD((pd)),
    .IGOVW(3026.8),
    .WEC(0.0),
    .RSH(0.0),
    .WVARL(0.0),
    .CSRHGATD(0.0001),
    .DELVTACO(0.0),
    .LPCK(3.171e-07),
    .AD((ad)),
    .CTGO(0.0),
    .STBETEDGEL(0.0),
    .VFBW(-0.027122),
    .GFACNUDO(1.0),
    .CJORBOTD(0.001),
    .ALPW(1.0825),
    .PSCEDEDGEO(0.0),
    .NSUBW(7.5708),
    .NFAEDGELW(8e+22),
    .TYPE(+1),
    .PBOTD(0.5),
    .CJORGAT((3e-11 * `sg13g2_lv_nmos_cjorgat)),
    .FNTEDGEO(1.0),
    .CTATGATD(0.0001),
    .PSTID(0.5),
    .LKVTHO(0.0),
    .CSLW(-0.00044184),
    .CFLEXP(3.9688),
    .TOXO((2.2404e-09 * `sg13g2_lv_nmos_toxo)),
    .PHIGBOTD(1.16),
    .ALP1L1(0.021138),
    .GFACNUDW(0.0),
    .CSRHSTI(0.0001),
    .LOVD(0.0),
    .RBULKO((rfmode * 0.002 * ng / w)),
    .STFBBTGAT(-0.001),
    .PBRGATD(4.0),
    .DPHIBEDGEL(0.0),
    .LPEDGE(1e-08),
    .RINT(1.3025e-11),
    .A3W(-0.041992),
    .NPCK(1.743e+21),
    .SWEDGE(0.0),
    .CGIDLO(0.06641),
    .MEFFTATSTID(0.25),
    .WEDGEW(0.0),
    .SWNQS((rfmode * 5.0)),
    .WLOD(0.0),
    .LVARW(0.0),
    .VBIRSTID(1.0),
    .NSUBO(1.0483e+23),
    .PHIGGATD(1.16),
    .DPHIBLW((-0.0036959 * `sg13g2_lv_nmos_dphiblw)),
    .RSHG((rfmode * 3.0)),
    .LINTNOI(-3.7e-08),
    .CFL(8.9001e-08),
    .SWGIDL(1.0),
    .WEB(0.0),
    .PSCELEXP(2.0),
    .CTEDGEL(0.0),
    .CFEDGELEXP(2.0),
    .A1W(-0.052179),
    .CFBEDGEO(0.0),
    .FACNEFFACL(0.0),
    .TR(27.0),
    .LKUO(0.0),
    .DLQ((-1.3721e-08 - ((1 - pre_layout) * 2e-08) + rfmode * (-1.5368e-08 + (ng < 3 ? 4e-08 : 0)))),
    .DELVTACLW(0.0),
    .CTO(0.054556),
    .STFBBTBOT(-0.001),
    .XJUNSTID(1e-07),
    .NGCON(2),
    .AXO(13.547),
    .A4O(0.04649),
    .XCORW(-0.10913),
    .SWIMPACT(1.0),
    .MEFFTATBOTD(0.25),
    .KVTHOWELW(0.0),
    .GCOO(10.0),
    .FBETEDGE(0.0),
    .ALP1LEXP(0.25),
    .STCTO(1.0),
    .IDSATRGAT(0.0),
    .RSHD(0.0),
    .XCORL(-0.11292),
    .CTATSTID(0.0001),
    .DPHIBO((-0.25737 * `sg13g2_lv_nmos_dphibo)),
    .PSCEDO(0.0),
    .STBGIDLO(0.0),
    .CSRHBOTD(100.0),
    .CFRW((((1 - rfmode) * 2e-16 + rfmode * (1e-18 + pre_layout * (ng > 0 ? 3.8525e-17 : 0))) / ng)),
    .STBETO(2.4165),
    .MULT((m)),
    .CFEDGEW(0.0),
    .FJUNQ(0.03),
    .CTATSTI(0.0001),
    .IDSATRBOTD(1e-12),
    .W((w)),
    .PSCEL(0.0),
    .CTATGAT(0.0001),
    .FACNEFFACW(0.0),
    .AS((as)),
    .VJUNREFD(2.5),
    .L((l)),
    .VPO(0.32224),
    .STTHECSO(0.0),
    .BGIDLDO(41.0),
    .PGAT(0.5424),
    .DELVTACW(0.0),
    .GFACNUDL(0.0),
    .NPL(0.0),
    .VNSUBO(0.0),
    .LVARO(0.0),
    .CSO(0.3164),
    .TRJ(21.0),
    .DPHIBEDGELEXP(1.0),
    .IDSATRGATD(1e-18),
    .STFBBTSTID(-0.001),
    .WEDGE(1e-08),
    .BGIDLO(19.92),
    .EPSROXO(3.9),
    .A1O(6.239),
    .STIGO(2.9949),
    .THESATLEXP(1.0316),
    .ST2VFBO(0.0),
    .WVARW(0.0),
    .NSUBEDGELW(0.0),
    .CFBO(0.6952),
    .KUOWEO(0.0),
    .MUNQSO(1.0),
    .NSLPO(0.05),
    .IDSATRSTI(1.9278e-15),
    .NOVO(3.5714e+25),
    .CSLEXP(1.1398),
    .CFDO(0.0),
    .PBRBOTD(4.0),
    .GFACNUDLEXP(1.0),
    .STBGIDLDO(0.0),
    .CFRDW(0.0),
    .STBETEDGEO(1.0),
    .TKUO(0.0),
    .SWDELVTAC(0.0),
    .VSBNUDO(0.0),
    .CTL((0.015058 * `sg13g2_lv_nmos_ctl)),
    .PSCEBEDGEO(0.0),
    .NPO(4.6457e+26),
    .QMC(1.0),
    .LAP(2.9423e-08),
    .VBRBOT(10.0),
    .A2O(17.75),
    .LLODKUO(0.0),
    .CBBTBOT(1e-12),
    .KVTHOWEO(0.0),
    .WKVTHO(0.0),
    .MEFFTATSTI(3.364),
    .CTW(-0.096878),
    .RJUNDO((rfmode * 5000.0 * l / w)),
    .STTHESATO(2.7784),
    .LPCKW(0.0),
    .DPHIBEDGEO(0.0),
    .VBIRGAT(2.0),
    .A3L(-0.045201),
    .NFBEDGELW(30000000.0),
    .THESATGO(0.1146),
    .ALP1L2(0.04044),
    .FBET2(-2.302),
    .CGIDLDO(0.0),
    .WBET(5.9171e-08),
    .VBIRGATD(1.0),
    .CSRHSTID(0.0001),
    .RVPOLY(0.0),
    .CTEDGELEXP(1.0),
    .FETAO(1.0),
    .A1L(0.052176),
    .VBRGATD(10.0),
    .CHIBO(3.1),
    .A4L(0.0),
    .STVFBL(2.8624e-05),
    .NFALW(7.616e+25),
    .NPCKW(-1.484),
    .CBBTSTID(1e-18),
    .PKUO(0.0),
    .WOT(-1e-08),
    .WSEG(5.3426e-06),
    .FACNEFFACO(1.0),
    .CJORBOT((0.00097636 * `sg13g2_lv_nmos_cjorbot)),
    .PBOT(0.31309),
    .PBRGAT(4.0),
    .THECSO(1.1822),
    .VBIRBOTD(1.0),
    .SWNUD(0.0),
    .AGIDLW(0.001262),
    .CTLW(0.008767),
    .VBRSTID(10.0),
    .GC2O(0.8413),
    .VBRGAT(10.0),
    .STBETL(-0.036997),
    .PHIGBOT(1.1136),
    .CSRHGAT(6.682e-06),
    .RSW2(0.0),
    .KUOWEW(0.0),
    .DPHIBW((0.0168 * `sg13g2_lv_nmos_dphibw)),
    .THESATBO(0.08213),
    .WKUO(0.0),
    .ALPL(0.0088345),
    .CGBOVL(4.4409e-28),
    .EFO(1.0),
    .XCORLW(-0.014959),
    .CSRHBOT(100.0),
    .MEFFTATGAT(0.25),
    .CTBO(0.0),
    .RJUNSO((rfmode * 5000.0 * l / w)),
    .CFW(-0.17956),
    .KVTHO(0.0),
    .PSCEEDGEW(0.0),
    .SCREF(1e-06),
    .STCSO(2.9406),
    .FREV(1000.0),
    .PS((ps)),
    .STBETLW(0.0062828),
    .PSCEW(0.0),
    .THEMUO((2.0546 * `sg13g2_lv_nmos_themuo)),
    .ALP2L2(0.0),
    .PKVTHO(0.0),
    .VBIRBOT(0.70829),
    .FBBTRBOTD(1000000000.0),
    .STBETW(0.0046613),
    .STTHESATLW(0.01292),
    .PBRSTI(4.0),
    .CBBTGAT(1e-18),
    .RSW1((130.0 * `sg13g2_lv_nmos_rsw1)),
    .STMUEO(0.98971),
    .IDSATRBOT(6.3087e-08),
    .FOL2(0.0021139),
    .LVARL(0.0),
    .STVFBEDGELW(0.0),
    .DPHIBEDGEW(0.0),
    .SWGEO(1.0),
    .PSCEBO(0.0),
    .DPHIBLEXP(0.068979),
    .STBETEDGEW(0.0),
    .STVFBEDGEW(0.0),
    .PSCEEDGEL(0.0),
    .STVFBO(0.00068785),
    .WSEGP(1e-08),
    .KUOWELW(0.0),
    .NSUBEDGEW(0.0),
    .DPHIBL((0.24027 * `sg13g2_lv_nmos_dphibl)),
    .XJUNSTI(1.5783e-07),
    .STVFBEDGEO(0.0005),
    .STTHESATW(-0.065908),
    .ALP1W(-0.077622),
    .STA2O(0.068723),
    .NSUBEDGELEXP(1.0),
    .PBRBOT(4.0),
    .VFBO((-0.94312 * (1 + (`sg13g2_lv_nmos_vfbo_mm - 1) / sqrt(m * l * w * 1e12)))),
    .FNTO(1.0),
    .FBET1W(0.38931),
    .MUEO(0.77874),
    .KVTHOWEW(0.0),
    .RSGO(0.074518),
    .PHIGSTID(1.16),
    .LP2(1.9441e-08),
    .SWIGN(1.0),
    .AGIDLDW(0.0),
    .KUOWEL(0.0),
    .DWQ((-1e-08 + rfmode * (4.8062e-07))),
    .DELVTACL(0.0),
    .CBBTSTI(1e-21),
    .MEFFTATBOT(5.204),
    .ALPLEXP(0.68143),
    .FBBTRGATD(1000000000.0),
    .VFBL(0.013965),
    .VFBLW(0.0044814),
    .NSUBEDGEL(0.0),
    .STVFBEDGEL(0.0),
    .CBBTGATD(1e-18),
    .STXCORO(2.0),
    .STFBBTBOTD(-0.001),
    .STFBBTGATD(-0.001),
    .XCORO(0.053934),
    .XJUNGAT(0.0001),
    .LP1W(-0.1544),
    .NFCLW(-5e-08),
    .VFBEDGEO(-1.0),
    .DELVTACLEXP(1.0),
    .BETW2(0.0087681),
    .TOXOVDO(2e-09),
    .PSTI(0.27362),
    .CJORSTID(1e-09),
    .A3O(0.708),
    .IGOVDW(0.0),
    .EFEDGEO(1.0),
    .CFEDGEL(0.0),
    .THESATL((0.43388 * `sg13g2_lv_nmos_thesatl)),
    .LODETAO(1.0),
    .PSCEEDGELEXP(2.0),
    .IMAX(0.0015358),
    .IDSATRSTID(1e-18),
    .PHIGGAT(1.16),
    .THESATLW((-0.0044 * `sg13g2_lv_nmos_thesatlw)),
    .CTLEXP(0.85719),
    .FBBTRSTID(1000000000.0),
    .FACNEFFACLW(0.0),
    .A4W(1.581e-16),
    .ALP2W(-0.13012),
    .STTHESATL(-0.091893),
    .LOV((2.9423e-08 - ((1 - pre_layout) * 9e-09))),
    .ALPNOI(1.869),
    .FBBTRGAT(1000000000.0),
    .SWJUNCAP(3.0),
    .SWJUNASYM(0.0),
    .RGO((rfmode * 40.0)),
    .KUO(0.0)
  ) M1 (node_d, node_g, node_s, node_b);
endmodule

module sg13_lv_pmos(node_d, node_g, node_s, node_b);
  inout node_d, node_g, node_s, node_b;
  electrical node_d, node_g, node_s, node_b;

  parameter integer _rdist_seed = 0;
  parameter real w = 0.35e-6;
  parameter real l = 0.28e-6;
  parameter real ng = 1;
  parameter real m = 1;
  parameter real as = 0;
  parameter real ad = 0;
  parameter real pd = 0;
  parameter real ps = 0;
  parameter real trise = 0;
  parameter real z1 = 0.34e-6;
  parameter real z2 = 0.38e-6;
  parameter real wmin = 0.15e-6;
  parameter real rfmode = 0;
  parameter real pre_layout = 1;

`include "sg13g2_moslv_parm.va"
  PSPNQS103VA #(
    .SWJUNEXP(0.0),
    .PHIGSTI(0.8186),
    .STETAO(0.0),
    .BETW1(-0.3268),
    .DTA(trise),
    .RSBO(0.06),
    .WLODVTH(0.0),
    .LLODVTH(0.0),
    .GFACNUDLW(0.0),
    .WVARO(0.0),
    .THESATO(0.099164),
    .FBBTRBOT(1000000000.0),
    .TOXOVO((1.9704e-09 * `sg13g2_lv_pmos_toxovo)),
    .FBET1(-0.2152),
    .ALP2LEXP(0.25),
    .STBETEDGELW(0.0),
    .SWIGATE(1.0),
    .VBRBOTD(10.0),
    .FJUNQD(0.03),
    .STFBBTSTI(-0.001),
    .CSW(-0.11045),
    .VBRSTI(10.0),
    .UO(0.017232),
    .MUEW((-0.067414 * `sg13g2_lv_pmos_muew)),
    .XJUNGATD(1e-07),
    .STVFBW(6.217e-06),
    .GC3O(-0.29543),
    .SBREF(1e-06),
    .FNTEXCL(0.0),
    .BETEDGEW(0.0),
    .CFDEDGEO(0.0),
    .SAREF(1e-06),
    .WLODKUO(0.0),
    .STRSO(-0.3508),
    .RWELLO((rfmode * 0.001 * ng / w)),
    .FBBTRSTI(1000000000.0),
    .IGINVLW((4880.4 * (1 + -5.803e-09 / l) * (1 + 5.1659e-08 / w))),
    .KVSAT(0.0),
    .NFBLW(572300000.0),
    .PGATD(0.5),
    .DNSUBO(0.039707),
    .ALP2L1(0.005286),
    .STTHEMUO(4.441e-15),
    .THESATW((-0.13745 * `sg13g2_lv_pmos_thesatw)),
    .VJUNREF(2.5),
    .MEFFTATGATD(0.25),
    .NF((ng)),
    .PBRSTID(4.0),
    .CTATBOT(100.0),
    .CJORSTI((3.1915e-11 * `sg13g2_lv_pmos_cjorsti)),
    .VBIRSTI(1.7036),
    .FOL1(-0.0081173),
    .CTATBOTD(100.0),
    .LP1(0.00019766),
    .KVTHOWEL(0.0),
    .AXL(0.58095),
    .CBBTBOTD(1e-12),
    .NOVDO(5e+25),
    .NSUBEDGEO(5e+23),
    .DVSBNUDO(1.0),
    .CTEDGEO(0.0),
    .DPHIBEDGELW(0.0),
    .CJORGATD(1e-09),
    .DLSIL(0.0),
    .NFCEDGELW(0.0),
    .STVFBLW(2.2668e-07),
    .CSL(0.34682),
    .PD((pd)),
    .IGOVW(1327.0),
    .WEC(0.0),
    .RSH(0.0),
    .WVARL(0.0),
    .CSRHGATD(0.0001),
    .DELVTACO(0.0),
    .LPCK(1.1576e-10),
    .AD((ad)),
    .CTGO(0.0),
    .STBETEDGEL(0.0),
    .VFBW(0.0071805),
    .GFACNUDO(1.0),
    .CJORBOTD(0.001),
    .ALPW(-0.21042),
    .PSCEDEDGEO(0.0),
    .NSUBW(-0.013639),
    .NFAEDGELW(8e+22),
    .TYPE(-1),
    .PBOTD(0.5),
    .CJORGAT((2.7474e-11 * `sg13g2_lv_pmos_cjorgat)),
    .FNTEDGEO(1.0),
    .CTATGATD(0.0001),
    .PSTID(0.5),
    .LKVTHO(0.0),
    .CSLW(0.014762),
    .CFLEXP(3.0355),
    .TOXO((1.9704e-09 * `sg13g2_lv_pmos_toxo)),
    .PHIGBOTD(1.16),
    .ALP1L1(0.0040221),
    .GFACNUDW(0.0),
    .CSRHSTI(0.0001),
    .LOVD(0.0),
    .RBULKO((rfmode * 0.002 * ng / w)),
    .STFBBTGAT(-0.001),
    .PBRGATD(4.0),
    .DPHIBEDGEL(0.0),
    .LPEDGE(1e-08),
    .RINT(1e-12),
    .A3W(-0.004911),
    .NPCK(5.7416e+24),
    .SWEDGE(0.0),
    .CGIDLO(0.02068),
    .MEFFTATSTID(0.25),
    .WEDGEW(0.0),
    .SWNQS((rfmode * 5.0)),
    .WLOD(0.0),
    .LVARW(0.0),
    .VBIRSTID(1.0),
    .NSUBO(4.6011e+23),
    .PHIGGATD(1.16),
    .DPHIBLW((-0.0030829 * `sg13g2_lv_pmos_dphiblw)),
    .RSHG((rfmode * 20.0)),
    .LINTNOI(1e-08),
    .CFL(0.00011247),
    .SWGIDL(1.0),
    .WEB(0.0),
    .PSCELEXP(2.0),
    .CTEDGEL(0.0),
    .CFEDGELEXP(2.0),
    .A1W(5.78),
    .CFBEDGEO(0.0),
    .FACNEFFACL(0.0),
    .TR(27.0),
    .LKUO(0.0),
    .DLQ((-9.5922e-08 - ((1 - pre_layout) * 3e-08) + rfmode * (-2e-08 + (ng < 3 ? 3.3917e-08 : 0)))),
    .DELVTACLW(0.0),
    .CTO(1.1814e-05),
    .STFBBTBOT(-0.001),
    .XJUNSTID(1e-07),
    .NGCON(2),
    .AXO(8.1825),
    .A4O(-0.005545),
    .XCORW(-0.095907),
    .SWIMPACT(1.0),
    .MEFFTATBOTD(0.25),
    .KVTHOWELW(0.0),
    .GCOO(0.01231),
    .FBETEDGE(0.0),
    .ALP1LEXP(0.6408),
    .STCTO(1.0),
    .IDSATRGAT(0.0),
    .RSHD(0.0),
    .XCORL(0.11698),
    .CTATSTID(0.0001),
    .DPHIBO((-0.099209 * `sg13g2_lv_pmos_dphibo)),
    .PSCEDO(0.0),
    .STBGIDLO(-0.0014941),
    .CSRHBOTD(100.0),
    .CFRW(((1e-16 + rfmode * (1e-18 + pre_layout * (ng > 0 ? 1.2382e-16 : 0))) / ng)),
    .STBETO(1.6974),
    .MULT((m)),
    .CFEDGEW(0.0),
    .FJUNQ(0.03),
    .CTATSTI(0.0001),
    .IDSATRBOTD(1e-12),
    .W((w)),
    .PSCEL(0.0),
    .CTATGAT(0.0001),
    .FACNEFFACW(0.0),
    .AS((as)),
    .VJUNREFD(2.5),
    .L((l)),
    .VPO(7.3803e-06),
    .STTHECSO(0.0),
    .BGIDLDO(41.0),
    .PGAT(0.6475),
    .DELVTACW(0.0),
    .GFACNUDL(0.0),
    .NPL(-0.095923),
    .VNSUBO(0.0),
    .LVARO(9.695e-08),
    .CSO(0.94214),
    .TRJ(21.0),
    .DPHIBEDGELEXP(1.0),
    .IDSATRGATD(1e-18),
    .STFBBTSTID(-0.001),
    .WEDGE(1e-08),
    .BGIDLO(15.12),
    .EPSROXO(3.9),
    .A1O(0.0001107),
    .STIGO(2.3506),
    .THESATLEXP(2.4434),
    .ST2VFBO(0.0),
    .WVARW(0.0),
    .NSUBEDGELW(0.0),
    .CFBO(0.57877),
    .KUOWEO(0.0),
    .MUNQSO(1.0),
    .NSLPO(0.05),
    .IDSATRSTI(1.1115e-15),
    .NOVO(3.104e+25),
    .CSLEXP(1.5813),
    .CFDO(0.0),
    .PBRBOTD(4.0),
    .GFACNUDLEXP(1.0),
    .STBGIDLDO(0.0),
    .CFRDW(0.0),
    .STBETEDGEO(1.0),
    .TKUO(0.0),
    .SWDELVTAC(0.0),
    .VSBNUDO(0.0),
    .CTL((0.0069387 * `sg13g2_lv_pmos_ctl)),
    .PSCEBEDGEO(0.0),
    .NPO(1.2699e+26),
    .QMC(1.0),
    .LAP(2.5254e-08),
    .VBRBOT(10.0),
    .A2O(13.33),
    .LLODKUO(0.0),
    .CBBTBOT(1e-12),
    .KVTHOWEO(0.0),
    .WKVTHO(0.0),
    .MEFFTATSTI(4.363),
    .CTW(0.36122),
    .RJUNDO((rfmode * 5000.0 * l / w)),
    .STTHESATO(12.733),
    .LPCKW(-0.022414),
    .DPHIBEDGEO(0.0),
    .VBIRGAT(1.399),
    .A3L(-0.08391),
    .NFBEDGELW(30000000.0),
    .THESATGO(0.0),
    .ALP1L2(1.611e-08),
    .FBET2(-6.171),
    .CGIDLDO(0.0),
    .WBET(5.424e-10),
    .VBIRGATD(1.0),
    .CSRHSTID(0.0001),
    .RVPOLY(0.0),
    .CTEDGELEXP(1.0),
    .FETAO(1.0),
    .A1L(5.741),
    .VBRGATD(10.0),
    .CHIBO(3.1),
    .A4L(0.2771),
    .STVFBL(2.4487e-06),
    .NFALW(2.209e+26),
    .NPCKW(-1.0),
    .CBBTSTID(1e-18),
    .PKUO(0.0),
    .WOT(1.5e-08),
    .WSEG(1.058e-08),
    .FACNEFFACO(1.0),
    .CJORBOT((0.00086306 * `sg13g2_lv_pmos_cjorbot)),
    .PBOT(0.3618),
    .PBRGAT(4.0),
    .THECSO(1.4566),
    .VBIRBOTD(1.0),
    .SWNUD(0.0),
    .AGIDLW(7.371e-05),
    .CTLW(-0.014902),
    .VBRSTID(10.0),
    .GC2O(0.54762),
    .VBRGAT(10.0),
    .STBETL(-0.037605),
    .PHIGBOT(1.204),
    .CSRHGAT(0.0001),
    .RSW2(-0.088444),
    .KUOWEW(0.0),
    .DPHIBW((-0.00069395 * `sg13g2_lv_pmos_dphibw)),
    .THESATBO(0.0),
    .WKUO(0.0),
    .ALPL(0.0047346),
    .CGBOVL(2.186e-17),
    .EFO(1.0),
    .XCORLW(0.029574),
    .CSRHBOT(100.0),
    .MEFFTATGAT(0.25),
    .CTBO(0.0),
    .RJUNSO((rfmode * 5000.0 * l / w)),
    .CFW(-0.012199),
    .KVTHO(0.0),
    .PSCEEDGEW(0.0),
    .SCREF(1e-06),
    .STCSO(1.0269),
    .FREV(1000.0),
    .PS((ps)),
    .STBETLW(0.0013663),
    .PSCEW(0.0),
    .THEMUO((1.3169 * `sg13g2_lv_pmos_themuo)),
    .ALP2L2(0.0),
    .PKVTHO(0.0),
    .VBIRBOT(0.7686),
    .FBBTRBOTD(1000000000.0),
    .STBETW(-0.0083384),
    .STTHESATLW(0.07117),
    .PBRSTI(4.0),
    .CBBTGAT(1e-18),
    .RSW1((697.38 * `sg13g2_lv_pmos_rsw1)),
    .STMUEO(0.84805),
    .IDSATRBOT(2.6746e-08),
    .FOL2(0.0081347),
    .LVARL(-0.03438),
    .STVFBEDGELW(0.0),
    .DPHIBEDGEW(0.0),
    .SWGEO(1.0),
    .PSCEBO(0.0),
    .DPHIBLEXP(2.9957),
    .STBETEDGEW(0.0),
    .STVFBEDGEW(0.0),
    .PSCEEDGEL(0.0),
    .STVFBO(0.00075111),
    .WSEGP(1e-10),
    .KUOWELW(0.0),
    .NSUBEDGEW(0.0),
    .DPHIBL((0.00020745 * `sg13g2_lv_pmos_dphibl)),
    .XJUNSTI(6.292e-08),
    .STVFBEDGEO(0.0005),
    .STTHESATW(-0.047465),
    .ALP1W(-0.057981),
    .STA2O(2.0),
    .NSUBEDGELEXP(1.0),
    .PBRBOT(4.0),
    .VFBO((-0.88703 * (1 + (`sg13g2_lv_pmos_vfbo_mm - 1) / sqrt(m * l * w * 1e12)))),
    .FNTO(1.85),
    .FBET1W(-0.065541),
    .MUEO(2.3326),
    .KVTHOWEW(0.0),
    .RSGO(0.495),
    .PHIGSTID(1.16),
    .LP2(1.2564e-08),
    .SWIGN(1.0),
    .AGIDLDW(0.0),
    .KUOWEL(0.0),
    .DWQ((1.5e-08 + rfmode * (4.7599e-07))),
    .DELVTACL(0.0),
    .CBBTSTI(1e-21),
    .MEFFTATBOT(10.0),
    .ALPLEXP(0.8468),
    .FBBTRGATD(1000000000.0),
    .VFBL(0.0089886),
    .VFBLW(0.004075),
    .NSUBEDGEL(0.0),
    .STVFBEDGEL(0.0),
    .CBBTGATD(1e-18),
    .STXCORO(2.7756e-17),
    .STFBBTBOTD(-0.001),
    .STFBBTGATD(-0.001),
    .XCORO(0.092591),
    .XJUNGAT(9.105e-05),
    .LP1W(0.0),
    .NFCLW(5.641e-07),
    .VFBEDGEO(-1.0),
    .DELVTACLEXP(1.0),
    .BETW2(0.060181),
    .TOXOVDO(2e-09),
    .PSTI(0.2548),
    .CJORSTID(1e-09),
    .A3O(1.526),
    .IGOVDW(0.0),
    .EFEDGEO(1.0),
    .CFEDGEL(0.0),
    .THESATL((0.010142 * `sg13g2_lv_pmos_thesatl)),
    .LODETAO(1.0),
    .PSCEEDGELEXP(2.0),
    .IMAX(0.0016551),
    .IDSATRSTID(1e-18),
    .PHIGGAT(1.65),
    .THESATLW((-0.103 * `sg13g2_lv_pmos_thesatlw)),
    .CTLEXP(1.4316),
    .FBBTRSTID(1000000000.0),
    .FACNEFFACLW(0.0),
    .A4W(0.7101),
    .ALP2W(0.063581),
    .STTHESATL(-1.9651),
    .LOV((2.5254e-08 - ((1 - pre_layout) * 8.85e-09))),
    .ALPNOI(2.118),
    .FBBTRGAT(1000000000.0),
    .SWJUNCAP(3.0),
    .SWJUNASYM(0.0),
    .RGO((rfmode * 22.0)),
    .KUO(0.0)
  ) M1 (node_d, node_g, node_s, node_b);
endmodule

module nmoscl_2(node_VDD, node_VSS);
  inout node_VDD, node_VSS;
  electrical node_VDD, node_VSS;

  parameter integer _rdist_seed = 0;
  parameter real l = 0.36e-6;
  parameter real w = 168e-6;
  parameter real m = 1;
  parameter real ng = 1;
  parameter real trise = 0;
  parameter real as = 58e-12;
  parameter real ad = 58e-12;
  parameter real pd = 336e-6;
  parameter real ps = 336e-6;
  parameter real rfmode = 0;
  parameter real pre_layout = 1;

`include "sg13g2_moslv_parm.va"
  PSPNQS103VA #(
    .SWJUNEXP(0.0),
    .PHIGSTI(1.3844),
    .STETAO(0.0),
    .BETW1(-0.020925),
    .DTA(trise),
    .RSBO(-0.099725),
    .WLODVTH(0.0),
    .LLODVTH(0.0),
    .GFACNUDLW(0.0),
    .WVARO(0.0),
    .THESATO(0.39843),
    .FBBTRBOT(1000000000.0),
    .TOXOVO((2.2404e-09 * `sg13g2_lv_nmos_toxovo)),
    .FBET1(12.168),
    .ALP2LEXP(0.25),
    .STBETEDGELW(0.0),
    .SWIGATE(1.0),
    .VBRBOTD(10.0),
    .FJUNQD(0.03),
    .STFBBTSTI(-0.001),
    .CSW(0.19805),
    .VBRSTI(10.0),
    .UO(0.045582),
    .MUEW((0.030943 * `sg13g2_lv_nmos_muew)),
    .XJUNGATD(1e-07),
    .STVFBW(-1.8689e-05),
    .GC3O(-0.4698),
    .SBREF(1e-06),
    .FNTEXCL(0.0),
    .BETEDGEW(0.0),
    .CFDEDGEO(0.0),
    .SAREF(1e-06),
    .WLODKUO(0.0),
    .STRSO(-0.49693),
    .RWELLO((rfmode * 0.002 * ng / w)),
    .FBBTRSTI(1000000000.0),
    .IGINVLW((121290.0 * (1 + 2.4761e-07 / l) * (1 + -2.1167e-08 / w))),
    .KVSAT(0.0),
    .NFBLW(1026000000.0),
    .PGATD(0.5),
    .DNSUBO(4.4409e-16),
    .ALP2L1(2.6817),
    .STTHEMUO(4.441e-15),
    .THESATW((0.12825 * `sg13g2_lv_nmos_thesatw)),
    .VJUNREF(2.5),
    .MEFFTATGATD(0.25),
    .NF((ng)),
    .PBRSTID(4.0),
    .CTATBOT(100.0),
    .CJORSTI((2.5279e-11 * `sg13g2_lv_nmos_cjorsti)),
    .VBIRSTI(0.79368),
    .FOL1(-0.0091066),
    .CTATBOTD(100.0),
    .LP1(5.1674e-09),
    .KVTHOWEL(0.0),
    .AXL(1.0186),
    .CBBTBOTD(1e-12),
    .NOVDO(5e+25),
    .NSUBEDGEO(5e+23),
    .DVSBNUDO(1.0),
    .CTEDGEO(0.0),
    .DPHIBEDGELW(0.0),
    .CJORGATD(1e-09),
    .DLSIL(0.0),
    .NFCEDGELW(0.0),
    .STVFBLW(5.1435e-07),
    .CSL(0.12341),
    .PD((pd)),
    .IGOVW(3026.8),
    .WEC(0.0),
    .RSH(0.0),
    .WVARL(0.0),
    .CSRHGATD(0.0001),
    .DELVTACO(0.0),
    .LPCK(3.171e-07),
    .AD((ad)),
    .CTGO(0.0),
    .STBETEDGEL(0.0),
    .VFBW(-0.027122),
    .GFACNUDO(1.0),
    .CJORBOTD(0.001),
    .ALPW(1.0825),
    .PSCEDEDGEO(0.0),
    .NSUBW(7.5708),
    .NFAEDGELW(8e+22),
    .TYPE(+1),
    .PBOTD(0.5),
    .CJORGAT((3e-11 * `sg13g2_lv_nmos_cjorgat)),
    .FNTEDGEO(1.0),
    .CTATGATD(0.0001),
    .PSTID(0.5),
    .LKVTHO(0.0),
    .CSLW(-0.00044184),
    .CFLEXP(3.9688),
    .TOXO((2.2404e-09 * `sg13g2_lv_nmos_toxo)),
    .PHIGBOTD(1.16),
    .ALP1L1(0.021138),
    .GFACNUDW(0.0),
    .CSRHSTI(0.0001),
    .LOVD(0.0),
    .RBULKO((rfmode * 0.002 * ng / w)),
    .STFBBTGAT(-0.001),
    .PBRGATD(4.0),
    .DPHIBEDGEL(0.0),
    .LPEDGE(1e-08),
    .RINT(1.3025e-11),
    .A3W(-0.041992),
    .NPCK(1.743e+21),
    .SWEDGE(0.0),
    .CGIDLO(0.06641),
    .MEFFTATSTID(0.25),
    .WEDGEW(0.0),
    .SWNQS((rfmode * 5.0)),
    .WLOD(0.0),
    .LVARW(0.0),
    .VBIRSTID(1.0),
    .NSUBO(1.0483e+23),
    .PHIGGATD(1.16),
    .DPHIBLW((-0.0036959 * `sg13g2_lv_nmos_dphiblw)),
    .RSHG((rfmode * 3.0)),
    .LINTNOI(-3.7e-08),
    .CFL(8.9001e-08),
    .SWGIDL(1.0),
    .WEB(0.0),
    .PSCELEXP(2.0),
    .CTEDGEL(0.0),
    .CFEDGELEXP(2.0),
    .A1W(-0.052179),
    .CFBEDGEO(0.0),
    .FACNEFFACL(0.0),
    .TR(27.0),
    .LKUO(0.0),
    .DLQ((-1.3721e-08 - ((1 - pre_layout) * 2e-08) + rfmode * (-1.5368e-08 + (ng < 3 ? 4e-08 : 0)))),
    .DELVTACLW(0.0),
    .CTO(0.054556),
    .STFBBTBOT(-0.001),
    .XJUNSTID(1e-07),
    .NGCON(2),
    .AXO(13.547),
    .A4O(0.04649),
    .XCORW(-0.10913),
    .SWIMPACT(1.0),
    .MEFFTATBOTD(0.25),
    .KVTHOWELW(0.0),
    .GCOO(10.0),
    .FBETEDGE(0.0),
    .ALP1LEXP(0.25),
    .STCTO(1.0),
    .IDSATRGAT(0.0),
    .RSHD(0.0),
    .XCORL(-0.11292),
    .CTATSTID(0.0001),
    .DPHIBO((-0.25737 * `sg13g2_lv_nmos_dphibo)),
    .PSCEDO(0.0),
    .STBGIDLO(0.0),
    .CSRHBOTD(100.0),
    .CFRW((((1 - rfmode) * 2e-16 + rfmode * (1e-18 + pre_layout * (ng > 0 ? 3.8525e-17 : 0))) / ng)),
    .STBETO(2.4165),
    .MULT((m)),
    .CFEDGEW(0.0),
    .FJUNQ(0.03),
    .CTATSTI(0.0001),
    .IDSATRBOTD(1e-12),
    .W((w)),
    .PSCEL(0.0),
    .CTATGAT(0.0001),
    .FACNEFFACW(0.0),
    .AS((as)),
    .VJUNREFD(2.5),
    .L((l)),
    .VPO(0.32224),
    .STTHECSO(0.0),
    .BGIDLDO(41.0),
    .PGAT(0.5424),
    .DELVTACW(0.0),
    .GFACNUDL(0.0),
    .NPL(0.0),
    .VNSUBO(0.0),
    .LVARO(0.0),
    .CSO(0.3164),
    .TRJ(21.0),
    .DPHIBEDGELEXP(1.0),
    .IDSATRGATD(1e-18),
    .STFBBTSTID(-0.001),
    .WEDGE(1e-08),
    .BGIDLO(19.92),
    .EPSROXO(3.9),
    .A1O(6.239),
    .STIGO(2.9949),
    .THESATLEXP(1.0316),
    .ST2VFBO(0.0),
    .WVARW(0.0),
    .NSUBEDGELW(0.0),
    .CFBO(0.6952),
    .KUOWEO(0.0),
    .MUNQSO(1.0),
    .NSLPO(0.05),
    .IDSATRSTI(1.9278e-15),
    .NOVO(3.5714e+25),
    .CSLEXP(1.1398),
    .CFDO(0.0),
    .PBRBOTD(4.0),
    .GFACNUDLEXP(1.0),
    .STBGIDLDO(0.0),
    .CFRDW(0.0),
    .STBETEDGEO(1.0),
    .TKUO(0.0),
    .SWDELVTAC(0.0),
    .VSBNUDO(0.0),
    .CTL((0.015058 * `sg13g2_lv_nmos_ctl)),
    .PSCEBEDGEO(0.0),
    .NPO(4.6457e+26),
    .QMC(1.0),
    .LAP(2.9423e-08),
    .VBRBOT(10.0),
    .A2O(17.75),
    .LLODKUO(0.0),
    .CBBTBOT(1e-12),
    .KVTHOWEO(0.0),
    .WKVTHO(0.0),
    .MEFFTATSTI(3.364),
    .CTW(-0.096878),
    .RJUNDO((rfmode * 5000.0 * l / w)),
    .STTHESATO(2.7784),
    .LPCKW(0.0),
    .DPHIBEDGEO(0.0),
    .VBIRGAT(2.0),
    .A3L(-0.045201),
    .NFBEDGELW(30000000.0),
    .THESATGO(0.1146),
    .ALP1L2(0.04044),
    .FBET2(-2.302),
    .CGIDLDO(0.0),
    .WBET(5.9171e-08),
    .VBIRGATD(1.0),
    .CSRHSTID(0.0001),
    .RVPOLY(0.0),
    .CTEDGELEXP(1.0),
    .FETAO(1.0),
    .A1L(0.052176),
    .VBRGATD(10.0),
    .CHIBO(3.1),
    .A4L(0.0),
    .STVFBL(2.8624e-05),
    .NFALW(7.616e+25),
    .NPCKW(-1.484),
    .CBBTSTID(1e-18),
    .PKUO(0.0),
    .WOT(-1e-08),
    .WSEG(5.3426e-06),
    .FACNEFFACO(1.0),
    .CJORBOT((0.00097636 * `sg13g2_lv_nmos_cjorbot)),
    .PBOT(0.31309),
    .PBRGAT(4.0),
    .THECSO(1.1822),
    .VBIRBOTD(1.0),
    .SWNUD(0.0),
    .AGIDLW(0.001262),
    .CTLW(0.008767),
    .VBRSTID(10.0),
    .GC2O(0.8413),
    .VBRGAT(10.0),
    .STBETL(-0.036997),
    .PHIGBOT(1.1136),
    .CSRHGAT(6.682e-06),
    .RSW2(0.0),
    .KUOWEW(0.0),
    .DPHIBW((0.0168 * `sg13g2_lv_nmos_dphibw)),
    .THESATBO(0.08213),
    .WKUO(0.0),
    .ALPL(0.0088345),
    .CGBOVL(4.4409e-28),
    .EFO(1.0),
    .XCORLW(-0.014959),
    .CSRHBOT(100.0),
    .MEFFTATGAT(0.25),
    .CTBO(0.0),
    .RJUNSO((rfmode * 5000.0 * l / w)),
    .CFW(-0.17956),
    .KVTHO(0.0),
    .PSCEEDGEW(0.0),
    .SCREF(1e-06),
    .STCSO(2.9406),
    .FREV(1000.0),
    .PS((ps)),
    .STBETLW(0.0062828),
    .PSCEW(0.0),
    .THEMUO((2.0546 * `sg13g2_lv_nmos_themuo)),
    .ALP2L2(0.0),
    .PKVTHO(0.0),
    .VBIRBOT(0.70829),
    .FBBTRBOTD(1000000000.0),
    .STBETW(0.0046613),
    .STTHESATLW(0.01292),
    .PBRSTI(4.0),
    .CBBTGAT(1e-18),
    .RSW1((130.0 * `sg13g2_lv_nmos_rsw1)),
    .STMUEO(0.98971),
    .IDSATRBOT(6.3087e-08),
    .FOL2(0.0021139),
    .LVARL(0.0),
    .STVFBEDGELW(0.0),
    .DPHIBEDGEW(0.0),
    .SWGEO(1.0),
    .PSCEBO(0.0),
    .DPHIBLEXP(0.068979),
    .STBETEDGEW(0.0),
    .STVFBEDGEW(0.0),
    .PSCEEDGEL(0.0),
    .STVFBO(0.00068785),
    .WSEGP(1e-08),
    .KUOWELW(0.0),
    .NSUBEDGEW(0.0),
    .DPHIBL((0.24027 * `sg13g2_lv_nmos_dphibl)),
    .XJUNSTI(1.5783e-07),
    .STVFBEDGEO(0.0005),
    .STTHESATW(-0.065908),
    .ALP1W(-0.077622),
    .STA2O(0.068723),
    .NSUBEDGELEXP(1.0),
    .PBRBOT(4.0),
    .VFBO((-0.94312 * (1 + (`sg13g2_lv_nmos_vfbo_mm - 1) / sqrt(m * l * w * 1e12)))),
    .FNTO(1.0),
    .FBET1W(0.38931),
    .MUEO(0.77874),
    .KVTHOWEW(0.0),
    .RSGO(0.074518),
    .PHIGSTID(1.16),
    .LP2(1.9441e-08),
    .SWIGN(1.0),
    .AGIDLDW(0.0),
    .KUOWEL(0.0),
    .DWQ((-1e-08 + rfmode * (4.8062e-07))),
    .DELVTACL(0.0),
    .CBBTSTI(1e-21),
    .MEFFTATBOT(5.204),
    .ALPLEXP(0.68143),
    .FBBTRGATD(1000000000.0),
    .VFBL(0.013965),
    .VFBLW(0.0044814),
    .NSUBEDGEL(0.0),
    .STVFBEDGEL(0.0),
    .CBBTGATD(1e-18),
    .STXCORO(2.0),
    .STFBBTBOTD(-0.001),
    .STFBBTGATD(-0.001),
    .XCORO(0.053934),
    .XJUNGAT(0.0001),
    .LP1W(-0.1544),
    .NFCLW(-5e-08),
    .VFBEDGEO(-1.0),
    .DELVTACLEXP(1.0),
    .BETW2(0.0087681),
    .TOXOVDO(2e-09),
    .PSTI(0.27362),
    .CJORSTID(1e-09),
    .A3O(0.708),
    .IGOVDW(0.0),
    .EFEDGEO(1.0),
    .CFEDGEL(0.0),
    .THESATL((0.43388 * `sg13g2_lv_nmos_thesatl)),
    .LODETAO(1.0),
    .PSCEEDGELEXP(2.0),
    .IMAX(0.0015358),
    .IDSATRSTID(1e-18),
    .PHIGGAT(1.16),
    .THESATLW((-0.0044 * `sg13g2_lv_nmos_thesatlw)),
    .CTLEXP(0.85719),
    .FBBTRSTID(1000000000.0),
    .FACNEFFACLW(0.0),
    .A4W(1.581e-16),
    .ALP2W(-0.13012),
    .STTHESATL(-0.091893),
    .LOV((2.9423e-08 - ((1 - pre_layout) * 9e-09))),
    .ALPNOI(1.869),
    .FBBTRGAT(1000000000.0),
    .SWJUNCAP(3.0),
    .SWJUNASYM(0.0),
    .RGO((rfmode * 40.0)),
    .KUO(0.0)
  ) M1 (node_VDD, node_VSS, node_VSS, node_VSS);
endmodule

module nmoscl_4(node_VDD, node_VSS);
  inout node_VDD, node_VSS;
  electrical node_VDD, node_VSS;

  parameter integer _rdist_seed = 0;
  parameter real l = 0.36e-6;
  parameter real w = 168e-6;
  parameter real m = 1;
  parameter real ng = 1;
  parameter real trise = 0;
  parameter real as = 114e-12;
  parameter real ad = 114e-12;
  parameter real pd = 672e-6;
  parameter real ps = 672e-6;
  parameter real rfmode = 0;
  parameter real pre_layout = 1;

`include "sg13g2_moslv_parm.va"
  PSPNQS103VA #(
    .SWJUNEXP(0.0),
    .PHIGSTI(1.3844),
    .STETAO(0.0),
    .BETW1(-0.020925),
    .DTA(trise),
    .RSBO(-0.099725),
    .WLODVTH(0.0),
    .LLODVTH(0.0),
    .GFACNUDLW(0.0),
    .WVARO(0.0),
    .THESATO(0.39843),
    .FBBTRBOT(1000000000.0),
    .TOXOVO((2.2404e-09 * `sg13g2_lv_nmos_toxovo)),
    .FBET1(12.168),
    .ALP2LEXP(0.25),
    .STBETEDGELW(0.0),
    .SWIGATE(1.0),
    .VBRBOTD(10.0),
    .FJUNQD(0.03),
    .STFBBTSTI(-0.001),
    .CSW(0.19805),
    .VBRSTI(10.0),
    .UO(0.045582),
    .MUEW((0.030943 * `sg13g2_lv_nmos_muew)),
    .XJUNGATD(1e-07),
    .STVFBW(-1.8689e-05),
    .GC3O(-0.4698),
    .SBREF(1e-06),
    .FNTEXCL(0.0),
    .BETEDGEW(0.0),
    .CFDEDGEO(0.0),
    .SAREF(1e-06),
    .WLODKUO(0.0),
    .STRSO(-0.49693),
    .RWELLO((rfmode * 0.002 * ng / w)),
    .FBBTRSTI(1000000000.0),
    .IGINVLW((121290.0 * (1 + 2.4761e-07 / l) * (1 + -2.1167e-08 / w))),
    .KVSAT(0.0),
    .NFBLW(1026000000.0),
    .PGATD(0.5),
    .DNSUBO(4.4409e-16),
    .ALP2L1(2.6817),
    .STTHEMUO(4.441e-15),
    .THESATW((0.12825 * `sg13g2_lv_nmos_thesatw)),
    .VJUNREF(2.5),
    .MEFFTATGATD(0.25),
    .NF((ng)),
    .PBRSTID(4.0),
    .CTATBOT(100.0),
    .CJORSTI((2.5279e-11 * `sg13g2_lv_nmos_cjorsti)),
    .VBIRSTI(0.79368),
    .FOL1(-0.0091066),
    .CTATBOTD(100.0),
    .LP1(5.1674e-09),
    .KVTHOWEL(0.0),
    .AXL(1.0186),
    .CBBTBOTD(1e-12),
    .NOVDO(5e+25),
    .NSUBEDGEO(5e+23),
    .DVSBNUDO(1.0),
    .CTEDGEO(0.0),
    .DPHIBEDGELW(0.0),
    .CJORGATD(1e-09),
    .DLSIL(0.0),
    .NFCEDGELW(0.0),
    .STVFBLW(5.1435e-07),
    .CSL(0.12341),
    .PD((pd)),
    .IGOVW(3026.8),
    .WEC(0.0),
    .RSH(0.0),
    .WVARL(0.0),
    .CSRHGATD(0.0001),
    .DELVTACO(0.0),
    .LPCK(3.171e-07),
    .AD((ad)),
    .CTGO(0.0),
    .STBETEDGEL(0.0),
    .VFBW(-0.027122),
    .GFACNUDO(1.0),
    .CJORBOTD(0.001),
    .ALPW(1.0825),
    .PSCEDEDGEO(0.0),
    .NSUBW(7.5708),
    .NFAEDGELW(8e+22),
    .TYPE(+1),
    .PBOTD(0.5),
    .CJORGAT((3e-11 * `sg13g2_lv_nmos_cjorgat)),
    .FNTEDGEO(1.0),
    .CTATGATD(0.0001),
    .PSTID(0.5),
    .LKVTHO(0.0),
    .CSLW(-0.00044184),
    .CFLEXP(3.9688),
    .TOXO((2.2404e-09 * `sg13g2_lv_nmos_toxo)),
    .PHIGBOTD(1.16),
    .ALP1L1(0.021138),
    .GFACNUDW(0.0),
    .CSRHSTI(0.0001),
    .LOVD(0.0),
    .RBULKO((rfmode * 0.002 * ng / w)),
    .STFBBTGAT(-0.001),
    .PBRGATD(4.0),
    .DPHIBEDGEL(0.0),
    .LPEDGE(1e-08),
    .RINT(1.3025e-11),
    .A3W(-0.041992),
    .NPCK(1.743e+21),
    .SWEDGE(0.0),
    .CGIDLO(0.06641),
    .MEFFTATSTID(0.25),
    .WEDGEW(0.0),
    .SWNQS((rfmode * 5.0)),
    .WLOD(0.0),
    .LVARW(0.0),
    .VBIRSTID(1.0),
    .NSUBO(1.0483e+23),
    .PHIGGATD(1.16),
    .DPHIBLW((-0.0036959 * `sg13g2_lv_nmos_dphiblw)),
    .RSHG((rfmode * 3.0)),
    .LINTNOI(-3.7e-08),
    .CFL(8.9001e-08),
    .SWGIDL(1.0),
    .WEB(0.0),
    .PSCELEXP(2.0),
    .CTEDGEL(0.0),
    .CFEDGELEXP(2.0),
    .A1W(-0.052179),
    .CFBEDGEO(0.0),
    .FACNEFFACL(0.0),
    .TR(27.0),
    .LKUO(0.0),
    .DLQ((-1.3721e-08 - ((1 - pre_layout) * 2e-08) + rfmode * (-1.5368e-08 + (ng < 3 ? 4e-08 : 0)))),
    .DELVTACLW(0.0),
    .CTO(0.054556),
    .STFBBTBOT(-0.001),
    .XJUNSTID(1e-07),
    .NGCON(2),
    .AXO(13.547),
    .A4O(0.04649),
    .XCORW(-0.10913),
    .SWIMPACT(1.0),
    .MEFFTATBOTD(0.25),
    .KVTHOWELW(0.0),
    .GCOO(10.0),
    .FBETEDGE(0.0),
    .ALP1LEXP(0.25),
    .STCTO(1.0),
    .IDSATRGAT(0.0),
    .RSHD(0.0),
    .XCORL(-0.11292),
    .CTATSTID(0.0001),
    .DPHIBO((-0.25737 * `sg13g2_lv_nmos_dphibo)),
    .PSCEDO(0.0),
    .STBGIDLO(0.0),
    .CSRHBOTD(100.0),
    .CFRW((((1 - rfmode) * 2e-16 + rfmode * (1e-18 + pre_layout * (ng > 0 ? 3.8525e-17 : 0))) / ng)),
    .STBETO(2.4165),
    .MULT((m)),
    .CFEDGEW(0.0),
    .FJUNQ(0.03),
    .CTATSTI(0.0001),
    .IDSATRBOTD(1e-12),
    .W((w)),
    .PSCEL(0.0),
    .CTATGAT(0.0001),
    .FACNEFFACW(0.0),
    .AS((as)),
    .VJUNREFD(2.5),
    .L((l)),
    .VPO(0.32224),
    .STTHECSO(0.0),
    .BGIDLDO(41.0),
    .PGAT(0.5424),
    .DELVTACW(0.0),
    .GFACNUDL(0.0),
    .NPL(0.0),
    .VNSUBO(0.0),
    .LVARO(0.0),
    .CSO(0.3164),
    .TRJ(21.0),
    .DPHIBEDGELEXP(1.0),
    .IDSATRGATD(1e-18),
    .STFBBTSTID(-0.001),
    .WEDGE(1e-08),
    .BGIDLO(19.92),
    .EPSROXO(3.9),
    .A1O(6.239),
    .STIGO(2.9949),
    .THESATLEXP(1.0316),
    .ST2VFBO(0.0),
    .WVARW(0.0),
    .NSUBEDGELW(0.0),
    .CFBO(0.6952),
    .KUOWEO(0.0),
    .MUNQSO(1.0),
    .NSLPO(0.05),
    .IDSATRSTI(1.9278e-15),
    .NOVO(3.5714e+25),
    .CSLEXP(1.1398),
    .CFDO(0.0),
    .PBRBOTD(4.0),
    .GFACNUDLEXP(1.0),
    .STBGIDLDO(0.0),
    .CFRDW(0.0),
    .STBETEDGEO(1.0),
    .TKUO(0.0),
    .SWDELVTAC(0.0),
    .VSBNUDO(0.0),
    .CTL((0.015058 * `sg13g2_lv_nmos_ctl)),
    .PSCEBEDGEO(0.0),
    .NPO(4.6457e+26),
    .QMC(1.0),
    .LAP(2.9423e-08),
    .VBRBOT(10.0),
    .A2O(17.75),
    .LLODKUO(0.0),
    .CBBTBOT(1e-12),
    .KVTHOWEO(0.0),
    .WKVTHO(0.0),
    .MEFFTATSTI(3.364),
    .CTW(-0.096878),
    .RJUNDO((rfmode * 5000.0 * l / w)),
    .STTHESATO(2.7784),
    .LPCKW(0.0),
    .DPHIBEDGEO(0.0),
    .VBIRGAT(2.0),
    .A3L(-0.045201),
    .NFBEDGELW(30000000.0),
    .THESATGO(0.1146),
    .ALP1L2(0.04044),
    .FBET2(-2.302),
    .CGIDLDO(0.0),
    .WBET(5.9171e-08),
    .VBIRGATD(1.0),
    .CSRHSTID(0.0001),
    .RVPOLY(0.0),
    .CTEDGELEXP(1.0),
    .FETAO(1.0),
    .A1L(0.052176),
    .VBRGATD(10.0),
    .CHIBO(3.1),
    .A4L(0.0),
    .STVFBL(2.8624e-05),
    .NFALW(7.616e+25),
    .NPCKW(-1.484),
    .CBBTSTID(1e-18),
    .PKUO(0.0),
    .WOT(-1e-08),
    .WSEG(5.3426e-06),
    .FACNEFFACO(1.0),
    .CJORBOT((0.00097636 * `sg13g2_lv_nmos_cjorbot)),
    .PBOT(0.31309),
    .PBRGAT(4.0),
    .THECSO(1.1822),
    .VBIRBOTD(1.0),
    .SWNUD(0.0),
    .AGIDLW(0.001262),
    .CTLW(0.008767),
    .VBRSTID(10.0),
    .GC2O(0.8413),
    .VBRGAT(10.0),
    .STBETL(-0.036997),
    .PHIGBOT(1.1136),
    .CSRHGAT(6.682e-06),
    .RSW2(0.0),
    .KUOWEW(0.0),
    .DPHIBW((0.0168 * `sg13g2_lv_nmos_dphibw)),
    .THESATBO(0.08213),
    .WKUO(0.0),
    .ALPL(0.0088345),
    .CGBOVL(4.4409e-28),
    .EFO(1.0),
    .XCORLW(-0.014959),
    .CSRHBOT(100.0),
    .MEFFTATGAT(0.25),
    .CTBO(0.0),
    .RJUNSO((rfmode * 5000.0 * l / w)),
    .CFW(-0.17956),
    .KVTHO(0.0),
    .PSCEEDGEW(0.0),
    .SCREF(1e-06),
    .STCSO(2.9406),
    .FREV(1000.0),
    .PS((ps)),
    .STBETLW(0.0062828),
    .PSCEW(0.0),
    .THEMUO((2.0546 * `sg13g2_lv_nmos_themuo)),
    .ALP2L2(0.0),
    .PKVTHO(0.0),
    .VBIRBOT(0.70829),
    .FBBTRBOTD(1000000000.0),
    .STBETW(0.0046613),
    .STTHESATLW(0.01292),
    .PBRSTI(4.0),
    .CBBTGAT(1e-18),
    .RSW1((130.0 * `sg13g2_lv_nmos_rsw1)),
    .STMUEO(0.98971),
    .IDSATRBOT(6.3087e-08),
    .FOL2(0.0021139),
    .LVARL(0.0),
    .STVFBEDGELW(0.0),
    .DPHIBEDGEW(0.0),
    .SWGEO(1.0),
    .PSCEBO(0.0),
    .DPHIBLEXP(0.068979),
    .STBETEDGEW(0.0),
    .STVFBEDGEW(0.0),
    .PSCEEDGEL(0.0),
    .STVFBO(0.00068785),
    .WSEGP(1e-08),
    .KUOWELW(0.0),
    .NSUBEDGEW(0.0),
    .DPHIBL((0.24027 * `sg13g2_lv_nmos_dphibl)),
    .XJUNSTI(1.5783e-07),
    .STVFBEDGEO(0.0005),
    .STTHESATW(-0.065908),
    .ALP1W(-0.077622),
    .STA2O(0.068723),
    .NSUBEDGELEXP(1.0),
    .PBRBOT(4.0),
    .VFBO((-0.94312 * (1 + (`sg13g2_lv_nmos_vfbo_mm - 1) / sqrt(m * l * w * 1e12)))),
    .FNTO(1.0),
    .FBET1W(0.38931),
    .MUEO(0.77874),
    .KVTHOWEW(0.0),
    .RSGO(0.074518),
    .PHIGSTID(1.16),
    .LP2(1.9441e-08),
    .SWIGN(1.0),
    .AGIDLDW(0.0),
    .KUOWEL(0.0),
    .DWQ((-1e-08 + rfmode * (4.8062e-07))),
    .DELVTACL(0.0),
    .CBBTSTI(1e-21),
    .MEFFTATBOT(5.204),
    .ALPLEXP(0.68143),
    .FBBTRGATD(1000000000.0),
    .VFBL(0.013965),
    .VFBLW(0.0044814),
    .NSUBEDGEL(0.0),
    .STVFBEDGEL(0.0),
    .CBBTGATD(1e-18),
    .STXCORO(2.0),
    .STFBBTBOTD(-0.001),
    .STFBBTGATD(-0.001),
    .XCORO(0.053934),
    .XJUNGAT(0.0001),
    .LP1W(-0.1544),
    .NFCLW(-5e-08),
    .VFBEDGEO(-1.0),
    .DELVTACLEXP(1.0),
    .BETW2(0.0087681),
    .TOXOVDO(2e-09),
    .PSTI(0.27362),
    .CJORSTID(1e-09),
    .A3O(0.708),
    .IGOVDW(0.0),
    .EFEDGEO(1.0),
    .CFEDGEL(0.0),
    .THESATL((0.43388 * `sg13g2_lv_nmos_thesatl)),
    .LODETAO(1.0),
    .PSCEEDGELEXP(2.0),
    .IMAX(0.0015358),
    .IDSATRSTID(1e-18),
    .PHIGGAT(1.16),
    .THESATLW((-0.0044 * `sg13g2_lv_nmos_thesatlw)),
    .CTLEXP(0.85719),
    .FBBTRSTID(1000000000.0),
    .FACNEFFACLW(0.0),
    .A4W(1.581e-16),
    .ALP2W(-0.13012),
    .STTHESATL(-0.091893),
    .LOV((2.9423e-08 - ((1 - pre_layout) * 9e-09))),
    .ALPNOI(1.869),
    .FBBTRGAT(1000000000.0),
    .SWJUNCAP(3.0),
    .SWJUNASYM(0.0),
    .RGO((rfmode * 40.0)),
    .KUO(0.0)
  ) M1 (node_VDD, node_VSS, node_VSS, node_VSS);
endmodule
