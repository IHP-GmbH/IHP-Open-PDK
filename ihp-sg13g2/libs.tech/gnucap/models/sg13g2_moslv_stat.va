`include "disciplines.vams"

`define sg13g2_lv_nmos_vfbo_mm (((0.01 <= 0) || (`mc_ok <= 0) ? `sg13g2_lv_nmos_vfbo_norm : $rdist_normal(_rdist_seed, `sg13g2_lv_nmos_vfbo_norm, (0.01 * `sg13g2_lv_nmos_vfbo_norm) / `mc_ok)))
`define sg13g2_lv_nmos_toxo (((0.0133 <= 0) || (`mc_ok <= 0) ? `sg13g2_lv_nmos_toxo_norm : $rdist_normal(_rdist_seed, `sg13g2_lv_nmos_toxo_norm, (0.0133 * `sg13g2_lv_nmos_toxo_norm) / `mc_ok)))
`define sg13g2_lv_nmos_dphibo (((0.0656 <= 0) || (`mc_ok <= 0) ? `sg13g2_lv_nmos_dphibo_norm : $rdist_normal(_rdist_seed, `sg13g2_lv_nmos_dphibo_norm, (0.0656 * `sg13g2_lv_nmos_dphibo_norm) / `mc_ok)))
`define sg13g2_lv_nmos_dphibl (((0.1135 <= 0) || (`mc_ok <= 0) ? `sg13g2_lv_nmos_dphibl_norm : $rdist_normal(_rdist_seed, `sg13g2_lv_nmos_dphibl_norm, (0.1135 * `sg13g2_lv_nmos_dphibl_norm) / `mc_ok)))
`define sg13g2_lv_nmos_dphibw (((0.1197 <= 0) || (`mc_ok <= 0) ? `sg13g2_lv_nmos_dphibw_norm : $rdist_normal(_rdist_seed, `sg13g2_lv_nmos_dphibw_norm, (0.1197 * `sg13g2_lv_nmos_dphibw_norm) / `mc_ok)))
`define sg13g2_lv_nmos_dphiblw (((0.0135 <= 0) || (`mc_ok <= 0) ? `sg13g2_lv_nmos_dphiblw_norm : $rdist_normal(_rdist_seed, `sg13g2_lv_nmos_dphiblw_norm, (0.0135 * `sg13g2_lv_nmos_dphiblw_norm) / `mc_ok)))
`define sg13g2_lv_nmos_toxovo (((0.0133 <= 0) || (`mc_ok <= 0) ? `sg13g2_lv_nmos_toxovo_norm : $rdist_normal(_rdist_seed, `sg13g2_lv_nmos_toxovo_norm, (0.0133 * `sg13g2_lv_nmos_toxovo_norm) / `mc_ok)))
`define sg13g2_lv_nmos_ctl (((0.1562 <= 0) || (`mc_ok <= 0) ? `sg13g2_lv_nmos_ctl_norm : $rdist_normal(_rdist_seed, `sg13g2_lv_nmos_ctl_norm, (0.1562 * `sg13g2_lv_nmos_ctl_norm) / `mc_ok)))
`define sg13g2_lv_nmos_muew (((0.032 <= 0) || (`mc_ok <= 0) ? `sg13g2_lv_nmos_muew_norm : $rdist_normal(_rdist_seed, `sg13g2_lv_nmos_muew_norm, (0.032 * `sg13g2_lv_nmos_muew_norm) / `mc_ok)))
`define sg13g2_lv_nmos_themuo (((0.0026 <= 0) || (`mc_ok <= 0) ? `sg13g2_lv_nmos_themuo_norm : $rdist_normal(_rdist_seed, `sg13g2_lv_nmos_themuo_norm, (0.0026 * `sg13g2_lv_nmos_themuo_norm) / `mc_ok)))
`define sg13g2_lv_nmos_rsw1 (((0.0407 <= 0) || (`mc_ok <= 0) ? `sg13g2_lv_nmos_rsw1_norm : $rdist_normal(_rdist_seed, `sg13g2_lv_nmos_rsw1_norm, (0.0407 * `sg13g2_lv_nmos_rsw1_norm) / `mc_ok)))
`define sg13g2_lv_nmos_thesatl (((0.0908 <= 0) || (`mc_ok <= 0) ? `sg13g2_lv_nmos_thesatl_norm : $rdist_normal(_rdist_seed, `sg13g2_lv_nmos_thesatl_norm, (0.0908 * `sg13g2_lv_nmos_thesatl_norm) / `mc_ok)))
`define sg13g2_lv_nmos_thesatw (((0.0272 <= 0) || (`mc_ok <= 0) ? `sg13g2_lv_nmos_thesatw_norm : $rdist_normal(_rdist_seed, `sg13g2_lv_nmos_thesatw_norm, (0.0272 * `sg13g2_lv_nmos_thesatw_norm) / `mc_ok)))
`define sg13g2_lv_nmos_thesatlw (((0.1503 <= 0) || (`mc_ok <= 0) ? `sg13g2_lv_nmos_thesatlw_norm : $rdist_normal(_rdist_seed, `sg13g2_lv_nmos_thesatlw_norm, (0.1503 * `sg13g2_lv_nmos_thesatlw_norm) / `mc_ok)))
`define sg13g2_lv_nmos_cjorbot (((0.0267 <= 0) || (`mc_ok <= 0) ? `sg13g2_lv_nmos_cjorbot_norm : $rdist_normal(_rdist_seed, `sg13g2_lv_nmos_cjorbot_norm, (0.0267 * `sg13g2_lv_nmos_cjorbot_norm) / `mc_ok)))
`define sg13g2_lv_nmos_cjorsti (((0.0267 <= 0) || (`mc_ok <= 0) ? `sg13g2_lv_nmos_cjorsti_norm : $rdist_normal(_rdist_seed, `sg13g2_lv_nmos_cjorsti_norm, (0.0267 * `sg13g2_lv_nmos_cjorsti_norm) / `mc_ok)))
`define sg13g2_lv_nmos_cjorgat (((0.0267 <= 0) || (`mc_ok <= 0) ? `sg13g2_lv_nmos_cjorgat_norm : $rdist_normal(_rdist_seed, `sg13g2_lv_nmos_cjorgat_norm, (0.0267 * `sg13g2_lv_nmos_cjorgat_norm) / `mc_ok)))
`define sg13g2_lv_pmos_vfbo_mm (((0.01 <= 0) || (`mc_ok <= 0) ? `sg13g2_lv_pmos_vfbo_norm : $rdist_normal(_rdist_seed, `sg13g2_lv_pmos_vfbo_norm, (0.01 * `sg13g2_lv_pmos_vfbo_norm) / `mc_ok)))
`define sg13g2_lv_pmos_toxo (((0.0133 <= 0) || (`mc_ok <= 0) ? `sg13g2_lv_pmos_toxo_norm : $rdist_normal(_rdist_seed, `sg13g2_lv_pmos_toxo_norm, (0.0133 * `sg13g2_lv_pmos_toxo_norm) / `mc_ok)))
`define sg13g2_lv_pmos_dphibo (((0.0656 <= 0) || (`mc_ok <= 0) ? `sg13g2_lv_pmos_dphibo_norm : $rdist_normal(_rdist_seed, `sg13g2_lv_pmos_dphibo_norm, (0.0656 * `sg13g2_lv_pmos_dphibo_norm) / `mc_ok)))
`define sg13g2_lv_pmos_dphibl (((0.1135 <= 0) || (`mc_ok <= 0) ? `sg13g2_lv_pmos_dphibl_norm : $rdist_normal(_rdist_seed, `sg13g2_lv_pmos_dphibl_norm, (0.1135 * `sg13g2_lv_pmos_dphibl_norm) / `mc_ok)))
`define sg13g2_lv_pmos_dphibw (((0.1197 <= 0) || (`mc_ok <= 0) ? `sg13g2_lv_pmos_dphibw_norm : $rdist_normal(_rdist_seed, `sg13g2_lv_pmos_dphibw_norm, (0.1197 * `sg13g2_lv_pmos_dphibw_norm) / `mc_ok)))
`define sg13g2_lv_pmos_dphiblw (((0.0135 <= 0) || (`mc_ok <= 0) ? `sg13g2_lv_pmos_dphiblw_norm : $rdist_normal(_rdist_seed, `sg13g2_lv_pmos_dphiblw_norm, (0.0135 * `sg13g2_lv_pmos_dphiblw_norm) / `mc_ok)))
`define sg13g2_lv_pmos_toxovo (((0.0133 <= 0) || (`mc_ok <= 0) ? `sg13g2_lv_pmos_toxovo_norm : $rdist_normal(_rdist_seed, `sg13g2_lv_pmos_toxovo_norm, (0.0133 * `sg13g2_lv_pmos_toxovo_norm) / `mc_ok)))
`define sg13g2_lv_pmos_ctl (((0.1562 <= 0) || (`mc_ok <= 0) ? `sg13g2_lv_pmos_ctl_norm : $rdist_normal(_rdist_seed, `sg13g2_lv_pmos_ctl_norm, (0.1562 * `sg13g2_lv_pmos_ctl_norm) / `mc_ok)))
`define sg13g2_lv_pmos_muew (((0.032 <= 0) || (`mc_ok <= 0) ? `sg13g2_lv_pmos_muew_norm : $rdist_normal(_rdist_seed, `sg13g2_lv_pmos_muew_norm, (0.032 * `sg13g2_lv_pmos_muew_norm) / `mc_ok)))
`define sg13g2_lv_pmos_themuo (((0.0026 <= 0) || (`mc_ok <= 0) ? `sg13g2_lv_pmos_themuo_norm : $rdist_normal(_rdist_seed, `sg13g2_lv_pmos_themuo_norm, (0.0026 * `sg13g2_lv_pmos_themuo_norm) / `mc_ok)))
`define sg13g2_lv_pmos_rsw1 (((0.0407 <= 0) || (`mc_ok <= 0) ? `sg13g2_lv_pmos_rsw1_norm : $rdist_normal(_rdist_seed, `sg13g2_lv_pmos_rsw1_norm, (0.0407 * `sg13g2_lv_pmos_rsw1_norm) / `mc_ok)))
`define sg13g2_lv_pmos_thesatl (((0.0908 <= 0) || (`mc_ok <= 0) ? `sg13g2_lv_pmos_thesatl_norm : $rdist_normal(_rdist_seed, `sg13g2_lv_pmos_thesatl_norm, (0.0908 * `sg13g2_lv_pmos_thesatl_norm) / `mc_ok)))
`define sg13g2_lv_pmos_thesatw (((0.0272 <= 0) || (`mc_ok <= 0) ? `sg13g2_lv_pmos_thesatw_norm : $rdist_normal(_rdist_seed, `sg13g2_lv_pmos_thesatw_norm, (0.0272 * `sg13g2_lv_pmos_thesatw_norm) / `mc_ok)))
`define sg13g2_lv_pmos_thesatlw (((0.1503 <= 0) || (`mc_ok <= 0) ? `sg13g2_lv_pmos_thesatlw_norm : $rdist_normal(_rdist_seed, `sg13g2_lv_pmos_thesatlw_norm, (0.1503 * `sg13g2_lv_pmos_thesatlw_norm) / `mc_ok)))
`define sg13g2_lv_pmos_cjorbot (((0.0267 <= 0) || (`mc_ok <= 0) ? `sg13g2_lv_pmos_cjorbot_norm : $rdist_normal(_rdist_seed, `sg13g2_lv_pmos_cjorbot_norm, (0.0267 * `sg13g2_lv_pmos_cjorbot_norm) / `mc_ok)))
`define sg13g2_lv_pmos_cjorsti (((0.0267 <= 0) || (`mc_ok <= 0) ? `sg13g2_lv_pmos_cjorsti_norm : $rdist_normal(_rdist_seed, `sg13g2_lv_pmos_cjorsti_norm, (0.0267 * `sg13g2_lv_pmos_cjorsti_norm) / `mc_ok)))
`define sg13g2_lv_pmos_cjorgat (((0.0267 <= 0) || (`mc_ok <= 0) ? `sg13g2_lv_pmos_cjorgat_norm : $rdist_normal(_rdist_seed, `sg13g2_lv_pmos_cjorgat_norm, (0.0267 * `sg13g2_lv_pmos_cjorgat_norm) / `mc_ok)))
