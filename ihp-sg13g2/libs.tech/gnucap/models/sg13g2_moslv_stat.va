`include "disciplines.vams"

`define sg13g2_lv_nmos_vfbo (`sg13g2_lv_nmos_vfbo_norm)
`define sg13g2_lv_nmos_toxo (`sg13g2_lv_nmos_toxo_norm)
`define sg13g2_lv_nmos_dphibo (`sg13g2_lv_nmos_dphibo_norm)
`define sg13g2_lv_nmos_dphibl (`sg13g2_lv_nmos_dphibl_norm)
`define sg13g2_lv_nmos_dphibw (`sg13g2_lv_nmos_dphibw_norm)
`define sg13g2_lv_nmos_dphiblw (`sg13g2_lv_nmos_dphiblw_norm)
`define sg13g2_lv_nmos_toxovo (`sg13g2_lv_nmos_toxovo_norm)
`define sg13g2_lv_nmos_ctl (`sg13g2_lv_nmos_ctl_norm)
`define sg13g2_lv_nmos_muew (`sg13g2_lv_nmos_muew_norm)
`define sg13g2_lv_nmos_themuo (`sg13g2_lv_nmos_themuo_norm)
`define sg13g2_lv_nmos_rsw1 (`sg13g2_lv_nmos_rsw1_norm)
`define sg13g2_lv_nmos_thesatl (`sg13g2_lv_nmos_thesatl_norm)
`define sg13g2_lv_nmos_thesatw (`sg13g2_lv_nmos_thesatw_norm)
`define sg13g2_lv_nmos_thesatlw (`sg13g2_lv_nmos_thesatlw_norm)
`define sg13g2_lv_nmos_cjorbot (`sg13g2_lv_nmos_cjorbot_norm)
`define sg13g2_lv_nmos_cjorsti (`sg13g2_lv_nmos_cjorsti_norm)
`define sg13g2_lv_nmos_cjorgat (`sg13g2_lv_nmos_cjorgat_norm)
`define sg13g2_lv_pmos_vfbo (`sg13g2_lv_pmos_vfbo_norm)
`define sg13g2_lv_pmos_toxo (`sg13g2_lv_pmos_toxo_norm)
`define sg13g2_lv_pmos_dphibo (`sg13g2_lv_pmos_dphibo_norm)
`define sg13g2_lv_pmos_dphibl (`sg13g2_lv_pmos_dphibl_norm)
`define sg13g2_lv_pmos_dphibw (`sg13g2_lv_pmos_dphibw_norm)
`define sg13g2_lv_pmos_dphiblw (`sg13g2_lv_pmos_dphiblw_norm)
`define sg13g2_lv_pmos_toxovo (`sg13g2_lv_pmos_toxovo_norm)
`define sg13g2_lv_pmos_ctl (`sg13g2_lv_pmos_ctl_norm)
`define sg13g2_lv_pmos_muew (`sg13g2_lv_pmos_muew_norm)
`define sg13g2_lv_pmos_themuo (`sg13g2_lv_pmos_themuo_norm)
`define sg13g2_lv_pmos_rsw1 (`sg13g2_lv_pmos_rsw1_norm)
`define sg13g2_lv_pmos_thesatl (`sg13g2_lv_pmos_thesatl_norm)
`define sg13g2_lv_pmos_thesatw (`sg13g2_lv_pmos_thesatw_norm)
`define sg13g2_lv_pmos_thesatlw (`sg13g2_lv_pmos_thesatlw_norm)
`define sg13g2_lv_pmos_cjorbot (`sg13g2_lv_pmos_cjorbot_norm)
`define sg13g2_lv_pmos_cjorsti (`sg13g2_lv_pmos_cjorsti_norm)
`define sg13g2_lv_pmos_cjorgat (`sg13g2_lv_pmos_cjorgat_norm)
