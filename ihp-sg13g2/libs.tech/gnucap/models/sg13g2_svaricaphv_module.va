//******************************************************************************
//
// Library:      SG13G2_dev
// Technologies: SG13G2
//
// Model:        MOSVAR 1.3
// Revision:     250311
//
//******************************************************************************
//
// Copyright 2026 IHP PDK Authors
//
// Licensed under the Apache License, Version 2.0 (the "License");
// you may not use this file except in compliance with the License.
// You may obtain a copy of the License at
//
//     https://www.apache.org/licenses/LICENSE-2.0
//
// Unless required by applicable law or agreed to in writing, software
// distributed under the License is distributed on an "AS IS" BASIS,
// WITHOUT WARRANTIES OR CONDITIONS OF ANY KIND, either express or implied.
// See the License for the specific language governing permissions and
// limitations under the License.
//
//******************************************************************************

//******************************************************************************
// SG13G2 High-Voltage MOS SVaricap modules
//
// Adapted from ngspice/models/sg13g2_svaricaphv_mod.lib
//
// Modifications:
// - Moved MOSVAR model cards and geometry mismatch into
//   paramsets/sg13g2_svaricaphv.va
// - Moved substrate diode model into paramsets/diode_dsubw.lib
// - Changed default width from 3u to the minimum supported width, 3.74u
// - Simplified expression for rww well resistance by assuming
//   rwellvw = rwellwvw = rwellnxvw = 0. Verilog-AMS parameters are constant and
//   can not depend dynamically on voltage. rwellvw, rwellwvw and rwellnxvw are now
//   unused
// - Removed dummy resistors
// - Dropped ic_<1e9 branch as Gnucap does not yet support conditional
//   instantiation via generate. ic_ is now unused.
//******************************************************************************

`include "disciplines.vams"

(* desc="SG13G2 High-Voltage MOS SVaricap module" *)
module sg13_hv_svaricap(G1, W, G2, bn);
    inout G1, W, G2, bn;
    electrical G1, W, G2, bn;

    electrical W0, W1, bi1, bi2, G2a;

    (* desc="Channel length", units="m" *)
    parameter real l = 600e-9 from [300n:800n];
    (* desc="Channel width", units="m" *)
    parameter real w = 3.74um from [3.74u:9.74u];
    (* desc="Number of fingers (Nx)" *)
    parameter integer Nx = 1 from [1:10];
    (* desc="Number of fingers (Ny)" *)
    parameter integer Ny = 1 from [1:1];
    (* desc="Temperature offset w.r.t. ambient" *)
    parameter real trise = 0.0;
    (* desc="Enable device mismatch" *)
    parameter integer mm_ok = 0 from [0:1];
    (* desc="Initial condition magnitude (>=1e9 disables ic on cic elements)" *)
    parameter real ic_ = 1e10;

    localparam real rwell0 = 32.85;
    localparam real rwellw = -2.499E+06;
    localparam real rwellnx = 4.759E+06;
    localparam real rwellvw = 0;
    localparam real rwellwvw = 0;
    localparam real rwellnxvw = 0;
    localparam real rsubw0 = 0.2596;
    localparam real rsubwf = 0.0009212;
    localparam real rsubwexp = 0.6952;
    localparam real ck0 = 4.267E-16;
    localparam real ckwnx = -7.948E-11;
    localparam real ckw = 1.252E-10;
    localparam real cic0 = 1E-18;
    localparam real vfbo = -0.04009;
    localparam real toxo = 6.945E-09;
    localparam real rk0 = 346.7;
    localparam real rkwnx = 0.000631;
    localparam real rwell = (rwell0 + rwellw * w) * Nx * Ny + rwellnx * w;
    localparam real dsubw_l = Nx * (0.38u + l) + 1.11e-6;
    localparam real dsubw_w = Ny * (w + 0.97e-6);
    localparam real dsubw_a = dsubw_l * dsubw_w;
    localparam real dsubw_p = 2.0 * (dsubw_l + dsubw_w);
    localparam real rsubw = rsubw0 / sqrt(pow(Nx, rsubwexp)) / (w + rsubwf);
    localparam real cg12 = (((ck0 + (ckw * w)) +((ckwnx * w)/(Nx * Ny)))* Nx)* Ny;
    localparam real rg12 = (rk0 + (rkwnx/w)) / (Nx*Ny);

    // add tiny element
    // TODO: ic_ <= 1e9 if branch missing
    capacitor #(.c(cic0)) Cic1(G1, W0);
    capacitor #(.c(cic0)) Cic2(G2, W0);
    // MOS Varactor 1
    sg13g2_hv_svaricap_psp #(
        .w(w),
        .l(l),
        .$mfactor(Nx * Ny),
        .dta(trise),
        .mm_ok(mm_ok)
    ) mvcap1(G1, bi1, W0);
    // MOS Varactor 2
    sg13g2_hv_svaricap_psp #(
        .w(w),
        .l(l),
        .$mfactor(Nx * Ny),
        .dta(trise),
        .mm_ok(mm_ok)
    ) mvcap2(G2, bi2, W0);
    // Well Parasitic
    resistor #(.r(rwell)) rww(W, W0);
    dsubw_mod #(.area(dsubw_a), .pj(dsubw_p)) dsubw(W1, W);
    resistor #(.r(rsubw)) rsubw(W1, bn);
    // Coupling G1 G2 capacitance with serial resistor
    capacitor #(.c(cg12)) ck_g12(G1, G2a);
    resistor  #(.r(rg12)) rk(G2a, G2);
endmodule
