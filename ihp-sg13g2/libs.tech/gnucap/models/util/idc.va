`include "disciplines.vams"

(* desc="vams idc" *)
module idc(p, n);
    output p, n;
    electrical p, n;

    parameter real dc = 0.0;

    analog begin
        I(p, n) <+ dc;
    end
endmodule
