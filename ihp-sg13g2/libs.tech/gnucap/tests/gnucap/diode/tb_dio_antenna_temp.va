module tb_dio_antenna_temp(a1, a2);
    inout a1, a2;
    electrical a1, a2;

    ground gnd;

    idc #(.dc(200n)) I0(gnd, a1);
    idc #(.dc(200n)) I1(gnd ,a2);
    dantenna  #(.l(780n), .w(780n)) D1(a1, gnd);
    dpantenna #(.l(780n), .w(780n)) D2(a2, gnd);
endmodule
