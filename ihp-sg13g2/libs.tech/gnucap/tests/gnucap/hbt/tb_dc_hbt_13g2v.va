load ../../../plugins/gnucap/s_dc_seed.so

load ../../../plugins/models/sg13g2_hbt_paramset.so
load ../../../plugins/models/idc.so
load ../../../plugins/models/sg13g2_hbt_module.so

module tb_dc_hbt_13g2v(b, c);
    // ports
    inout b, c;
    electrical b, c;
    // testbench parameters
    parameter real vce = 0.0;
    parameter real ib = 0.0;
    parameter integer Nx = 1 from [1:4];
    parameter real El = 2.5 from [1:5];

    ground gnd;

    vsource #(.dc(vce)) vce_src(c, gnd);
    idc #(.dc(ib)) ib_src(gnd, b_probe);
    vsource #(.dc(0.0)) vb_src(b_probe, b);
    npn13G2v #(.Nx(Nx), .mm_ok(0), .El(El)) q1(c, b, gnd, gnd);
endmodule
