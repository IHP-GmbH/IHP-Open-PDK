load ../../../plugins/models/sg13g2_hbt_paramset.so
load ../../../plugins/models/idc.so
load ../../../plugins/models/sg13g2_hbt_module.so

module tb_mc_hbt_13g2();
    electrical b, c;
    parameter integer mm_ok = 0 from [0:1];

    ground gnd;

    vsource #(.dc(1.5)) vce(c, gnd);
    idc #(.dc(1u)) i0(gnd, b);
    npn13G2 #(.Nx(1), .mm_ok(mm_ok)) q1(c, b, gnd, gnd);
endmodule
