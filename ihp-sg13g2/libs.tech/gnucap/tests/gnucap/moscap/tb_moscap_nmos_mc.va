`include ../../../models/sg13g2_moscap_module.va

module tb_moscap_nmos_mc(outn);
    inout outn;
    electrical outn;
    electrical inn;
    parameter integer mm_ok = 0 from [0:1];
    ground gnd;

    vsine #(.mag(1), .dc(-1.2)) V1(inn, gnd);
    resistor #(.r(100k)) Rser(inn, outn);
    sg13_moscap_n #(.w(1.0u), .l(1.0u), .mm_ok(mm_ok)) C1(outn, gnd);
endmodule
