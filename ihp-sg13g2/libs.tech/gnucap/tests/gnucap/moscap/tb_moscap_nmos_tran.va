`include ../../../models/sg13g2_moscap_module.va

module tb_moscap_nmos_tran(g);
    inout g;
    electrical out;
    ground gnd;

    vpulse #(.val0(-1.2), .val1(1.2), .td(10n), .rise(400n)) V1(g, gnd);
    sg13_moscap_n #(.w(1.0u), .l(1.0u), .m(1)) C1(g, gnd);
endmodule
