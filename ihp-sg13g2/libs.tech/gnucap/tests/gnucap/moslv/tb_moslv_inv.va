// load model plugins
load ../../../plugins/models/sg13g2_moslv_paramset.so
load ../../../plugins/models/sg13g2_moslv_rf_paramset.so
// load model module plugin
load ../../../plugins/models/sg13g2_moslv_module.so

// TODO: revisit iteration limit and convergence issues
options itl6=150

module tb_moslv_inv(in, out);
    // external ports
    input in;
    output out;
    electrical in, out;
    // internal nodes
    electrical vdd;
    // testbench parameters
    parameter integer rfmode = 0 from [0:1]; // switch for rf
    parameter real vin_dc; // input DC voltage
    parameter real vdd_dc = 1.2; // supply voltage
    ground gnd;
    // inverter under test
    vsource #(.dc(vdd_dc)) vdd_src(vdd, gnd);
    vsource #(.dc(vin_dc)) vin_src(in, gnd);
    sg13_lv_pmos #(.w(0.28u), .l(0.34u), .mm_ok(0), .rfmode(rfmode)) P1(out, in, vdd, vdd);
    sg13_lv_nmos #(.w(0.35u), .l(0.34u), .mm_ok(0), .rfmode(rfmode)) N1(out, in, gnd, gnd);
endmodule
