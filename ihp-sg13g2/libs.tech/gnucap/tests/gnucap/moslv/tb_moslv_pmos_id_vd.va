// load moslv model plugin
load ../../../plugins/models/sg13g2_moslv_paramset.so
load ../../../plugins/models/sg13g2_moslv_rf_paramset.so
// load moslv module wrapper plugin
load ../../../plugins/models/sg13g2_moslv_module.so

module tb_pmos_dc(d, g);
    // external ports
    inout d, g;
    electrical d, g;
    // testbench parameters
    parameter integer rfmode = 0 from [0:1]; // rf model switch
    parameter real vd = 0.0;
    parameter real vg = 0.0;
    parameter real w = 0.28u;
    parameter integer ng = 1;
    ground gnd;
    vsource #(.dc(vd)) sd(d, gnd);
    vsource #(.dc(vg)) sg(g, gnd);
    sg13_lv_pmos #(.w(w), .l(0.34u), .ng(ng), .mm_ok(0), .rfmode(rfmode)) M1(d, g, gnd, gnd);
endmodule
