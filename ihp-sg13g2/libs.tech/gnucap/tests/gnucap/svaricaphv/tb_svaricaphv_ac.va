module tb_svaricaphv_ac();
    electrical G1, W, G2, wb;
    parameter real w = 3.74u;
    parameter real l = 0.3u;
    parameter integer Nx = 1 from [1:10];
    parameter integer mm_ok = 0 from [0:1];

    ground gnd;

    vsource  #(.dc(1.0))  VW(wb, gnd);
    inductor #(.l(1.0m))  L1(W, wb);
    vsine    #(.mag(1.0)) VG1(G1, gnd);
    vsource  #(.dc(0.0))  VG2(G2, gnd);

    sg13_hv_svaricap #(.w(w), .l(l), .Nx(Nx), .mm_ok(mm_ok)) C1(G1, W, G2, gnd);
endmodule
