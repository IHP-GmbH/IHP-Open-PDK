*==========================================================================
* Copyright 2026 IHP PDK Authors
*
* Licensed under the Apache License, Version 2.0 (the "License");
* you may not use this file except in compliance with the License.
* You may obtain a copy of the License at
*
*    https://www.apache.org/licenses/LICENSE-2.0
*
* Unless required by applicable law or agreed to in writing, software
* distributed under the License is distributed on an "AS IS" BASIS,
* WITHOUT WARRANTIES OR CONDITIONS OF ANY KIND, either express or implied.
* See the License for the specific language governing permissions and
* limitations under the License.
* SPDX-License-Identifier: Apache-2.0
*==========================================================================
* cmomf_all_dropped.gds: the merged-marker construction with nothing else in the
* cell, so every device in it is skipped.
*
* Expected to end in an extraction ERROR. If the extractor only logged the
* skipped marker, the circuit would be left with no devices, drop out of the
* layout netlist, and the comparison would match any schematic at all: this
* two-cap netlist would pass against a layout that extracted none. The error()
* in custom_mom_extractor.lvs is the only thing standing in the way here, which
* is why this case keeps the malformed-only shape instead of carrying a well
* formed cap alongside.
.SUBCKT cmomf_all_dropped
C1 P1 M1 cap_cmomf w=5e-06 l=5e-06 mmin=1 mmax=5
C2 P2 M2 cap_cmomf w=5e-06 l=5e-06 mmin=1 mmax=5
.ENDS cmomf_all_dropped
