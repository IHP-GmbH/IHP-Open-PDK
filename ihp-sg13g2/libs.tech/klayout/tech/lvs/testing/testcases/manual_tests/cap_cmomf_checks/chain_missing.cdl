*==========================================================================
* Copyright 2026 IHP PDK Authors
*
* Licensed under the Apache License, Version 2.0 (the "License");
* you may not use this file except in compliance with the License.
* You may obtain a copy of the License at
*
*    https://www.apache.org/licenses/LICENSE-2.0
*
* Unless required by applicable law or agreed to in writing, software
* distributed under the License is distributed on an "AS IS" BASIS,
* WITHOUT WARRANTIES OR CONDITIONS OF ANY KIND, either express or implied.
* See the License for the specific language governing permissions and
* limitations under the License.
* SPDX-License-Identifier: Apache-2.0
*==========================================================================
* cmomf_chain.gds with the last cap left out of the schematic.
*
* The plainest thing LVS has to catch: a device present in the layout and
* absent from the netlist. If this ever passes, nothing else in this suite
* means anything.
.SUBCKT cmomf_chain
C1 A  N1 cap_cmomf w=5e-06 l=5e-06 mmin=1 mmax=5
C2 N1 N2 cap_cmomf w=5e-06 l=5e-06 mmin=1 mmax=5
.ENDS cmomf_chain
