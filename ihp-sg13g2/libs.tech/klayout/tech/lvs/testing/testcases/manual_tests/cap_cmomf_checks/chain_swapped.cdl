*==========================================================================
* Copyright 2026 IHP PDK Authors
*
* Licensed under the Apache License, Version 2.0 (the "License");
* you may not use this file except in compliance with the License.
* You may obtain a copy of the License at
*
*    https://www.apache.org/licenses/LICENSE-2.0
*
* Unless required by applicable law or agreed to in writing, software
* distributed under the License is distributed on an "AS IS" BASIS,
* WITHOUT WARRANTIES OR CONDITIONS OF ANY KIND, either express or implied.
* See the License for the specific language governing permissions and
* limitations under the License.
* SPDX-License-Identifier: Apache-2.0
*==========================================================================
* cmomf_chain.gds with the middle cap's two terminals exchanged.
*
* The connectivity graph is identical to chain_match; only the order of two net
* names on one C-line differs. The extractor picks the two ports by geometry and
* never reads their pin names, so the order it produces carries no information:
* it sorts by x, and the PCell puts PLUS on the left edge and MINUS on the top
* one. DeviceCustomMIM therefore declares the two terminals equivalent.
*
* Expected to PASS. cmomf_mirrored.gds is the same statement made in layout
* rather than in the netlist, and is the case that actually bites in practice.
.SUBCKT cmomf_chain
C1 A  N1 cap_cmomf w=5e-06 l=5e-06 mmin=1 mmax=5
C2 N2 N1 cap_cmomf w=5e-06 l=5e-06 mmin=1 mmax=5
C3 N2 B  cap_cmomf w=5e-06 l=5e-06 mmin=1 mmax=5
.ENDS cmomf_chain
