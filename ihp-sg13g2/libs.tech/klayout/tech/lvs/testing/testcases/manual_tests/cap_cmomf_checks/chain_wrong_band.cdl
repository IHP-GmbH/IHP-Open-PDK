*==========================================================================
* Copyright 2026 IHP PDK Authors
*
* Licensed under the Apache License, Version 2.0 (the "License");
* you may not use this file except in compliance with the License.
* You may obtain a copy of the License at
*
*    https://www.apache.org/licenses/LICENSE-2.0
*
* Unless required by applicable law or agreed to in writing, software
* distributed under the License is distributed on an "AS IS" BASIS,
* WITHOUT WARRANTIES OR CONDITIONS OF ANY KIND, either express or implied.
* See the License for the specific language governing permissions and
* limitations under the License.
* SPDX-License-Identifier: Apache-2.0
*==========================================================================
* cmomf_chain.gds with the middle cap declared on Metal4..Metal5 against a
* Metal1..Metal5 layout.
*
* mmin and mmax reach the SPICE reader and are then dropped: they are not device
* parameters. The footprint and the marker bounding box do not depend on the
* band either, so the two devices are indistinguishable to the deck while their
* capacitance differs by a factor of two and a half at these numbers.
*
* Expected to PASS, and this is the most consequential of the recorded
* limitations. cap_cmomi has the same hole, for the same reason. The pins do sit
* on the mmax metal, so the port layer that fired is not nothing, but the
* extractor does not record it and CapMomExtractor treats m1p..m5p alike.
* Deriving the band from the geometry instead is not a fix: metalN.and(marker)
* cannot tell the device's own metal from routing that crosses over it.
.SUBCKT cmomf_chain
C1 A  N1 cap_cmomf w=5e-06 l=5e-06 mmin=1 mmax=5
C2 N1 N2 cap_cmomf w=5e-06 l=5e-06 mmin=4 mmax=5
C3 N2 B  cap_cmomf w=5e-06 l=5e-06 mmin=1 mmax=5
.ENDS cmomf_chain
