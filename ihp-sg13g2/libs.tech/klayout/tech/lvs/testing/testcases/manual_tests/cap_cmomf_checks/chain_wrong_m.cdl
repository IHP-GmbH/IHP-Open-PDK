*==========================================================================
* Copyright 2026 IHP PDK Authors
*
* Licensed under the Apache License, Version 2.0 (the "License");
* you may not use this file except in compliance with the License.
* You may obtain a copy of the License at
*
*    https://www.apache.org/licenses/LICENSE-2.0
*
* Unless required by applicable law or agreed to in writing, software
* distributed under the License is distributed on an "AS IS" BASIS,
* WITHOUT WARRANTIES OR CONDITIONS OF ANY KIND, either express or implied.
* See the License for the specific language governing permissions and
* limitations under the License.
* SPDX-License-Identifier: Apache-2.0
*==========================================================================
* cmomf_chain.gds with the middle cap declared m=2 against a single placement.
*
* m is declared is_primary=true on DeviceCustomMIM, so it looks compared, but
* CustomReader intercepts every C element and map_capacitor_params only sets m
* when the model name contains 'mim'. cap_cmomf does not, so the value is read
* off the card and dropped and both sides keep the class default of 1.
*
* Expected to PASS. It matters because m is the only token beyond w and l that
* the xschem symbol's lvs_format emits, so a designer who arrays the device
* through m gets no check at all. Anyone fixing this should look at that 'mim'
* substring gate in the shared custom_reader.lvs, not at multiplier handling.
.SUBCKT cmomf_chain
C1 A  N1 cap_cmomf w=5e-06 l=5e-06 mmin=1 mmax=5
C2 N1 N2 cap_cmomf w=5e-06 l=5e-06 mmin=1 mmax=5 m=2
C3 N2 B  cap_cmomf w=5e-06 l=5e-06 mmin=1 mmax=5
.ENDS cmomf_chain
