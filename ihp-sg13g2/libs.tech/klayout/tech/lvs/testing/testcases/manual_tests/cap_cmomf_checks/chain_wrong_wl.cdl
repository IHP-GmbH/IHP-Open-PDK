*==========================================================================
* Copyright 2026 IHP PDK Authors
*
* Licensed under the Apache License, Version 2.0 (the "License");
* you may not use this file except in compliance with the License.
* You may obtain a copy of the License at
*
*    https://www.apache.org/licenses/LICENSE-2.0
*
* Unless required by applicable law or agreed to in writing, software
* distributed under the License is distributed on an "AS IS" BASIS,
* WITHOUT WARRANTIES OR CONDITIONS OF ANY KIND, either express or implied.
* See the License for the specific language governing permissions and
* limitations under the License.
* SPDX-License-Identifier: Apache-2.0
*==========================================================================
* cmomf_chain.gds with the middle cap declared 99u x 1u against a 5x5 layout.
*
* Both w and l are added to DeviceCustomMIM with is_primary=false, so neither is
* compared. The extractor does record them, from the Recog.momf bounding box, and
* the .cir shows the drawn values, but the comparison never looks.
*
* Expected to PASS. That is the finding, not a gap in the case: cap_cmomf is
* matched topologically, exactly as cap_cmomi is.
.SUBCKT cmomf_chain
C1 A  N1 cap_cmomf w=5e-06 l=5e-06 mmin=1 mmax=5
C2 N1 N2 cap_cmomf w=99e-06 l=1e-06 mmin=1 mmax=5
C3 N2 B  cap_cmomf w=5e-06 l=5e-06 mmin=1 mmax=5
.ENDS cmomf_chain
