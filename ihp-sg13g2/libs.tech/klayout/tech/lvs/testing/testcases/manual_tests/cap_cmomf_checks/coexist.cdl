*==========================================================================
* Copyright 2026 IHP PDK Authors
*
* Licensed under the Apache License, Version 2.0 (the "License");
* you may not use this file except in compliance with the License.
* You may obtain a copy of the License at
*
*    https://www.apache.org/licenses/LICENSE-2.0
*
* Unless required by applicable law or agreed to in writing, software
* distributed under the License is distributed on an "AS IS" BASIS,
* WITHOUT WARRANTIES OR CONDITIONS OF ANY KIND, either express or implied.
* See the License for the specific language governing permissions and
* limitations under the License.
* SPDX-License-Identifier: Apache-2.0
*==========================================================================
* One cap_cmomf beside one cap_cmomi, both on Metal1..Metal5.
*
* The two devices are extracted by two instances of the same CapMomExtractor and
* are told apart by nothing but their recognition marker: 99/39 for cap_cmomi,
* 99/40 for cap_cmomf. Sharing one marker would make a single geometry extract
* as both devices and fail on the device count, which is the reason cap_cmomf
* carries its own.
*
* Expected to PASS, with exactly one device of each class. There is no case like
* this on the cap_cmomi side: the marker split only has two ends once the second
* device exists.
*
* The declared dimensions are the drawn ones for cap_cmomf and are quantized to
* the finger pitch for cap_cmomi, which is why they differ from the 4x12 both
* were asked for. Neither is compared.
.SUBCKT cmomf_coexist
C1 P1 M1 cap_cmomf w=4e-06 l=12e-06 mmin=1 mmax=5
C2 P2 M2 cap_cmomi w=4.2e-06 l=13.56e-06 mmin=1 mmax=5 feed=double
.ENDS cmomf_coexist
