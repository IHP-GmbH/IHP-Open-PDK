*==========================================================================
* Copyright 2026 IHP PDK Authors
*
* Licensed under the Apache License, Version 2.0 (the "License");
* you may not use this file except in compliance with the License.
* You may obtain a copy of the License at
*
*    https://www.apache.org/licenses/LICENSE-2.0
*
* Unless required by applicable law or agreed to in writing, software
* distributed under the License is distributed on an "AS IS" BASIS,
* WITHOUT WARRANTIES OR CONDITIONS OF ANY KIND, either express or implied.
* See the License for the specific language governing permissions and
* limitations under the License.
* SPDX-License-Identifier: Apache-2.0
*==========================================================================
* Two caps in series, each in its own sub-cell, joined by a top-level route.
*
* The deep-mode counterpart of the hierarchical case above, and the reason both
* exist. That one runs a hierarchy where nothing crosses a cell boundary and
* passes vacuously; this one is the same hierarchy with one Metal5 route drawn
* in the top cell, and passes on a real comparison. Together they say what
* actually triggers the hole: not sub-cells, but a sub-circuit that ends up with
* no pins.
*
* Without this case the suite would be blind in the direction that matters: with
* deep extraction broken outright the vacuous case would still report a match,
* and nothing would notice.
*
* Layout generated by create_cap_cmomf_testcases.py.
.SUBCKT cmomf_hier_wired
C1 A  N1 cap_cmomf w=5e-06 l=5e-06 mmin=1 mmax=5
C2 N1 B  cap_cmomf w=5e-06 l=5e-06 mmin=1 mmax=5
.ENDS cmomf_hier_wired
