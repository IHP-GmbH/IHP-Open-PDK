*==========================================================================
* Copyright 2026 IHP PDK Authors
*
* Licensed under the Apache License, Version 2.0 (the "License");
* you may not use this file except in compliance with the License.
* You may obtain a copy of the License at
*
*    https://www.apache.org/licenses/LICENSE-2.0
*
* Unless required by applicable law or agreed to in writing, software
* distributed under the License is distributed on an "AS IS" BASIS,
* WITHOUT WARRANTIES OR CONDITIONS OF ANY KIND, either express or implied.
* See the License for the specific language governing permissions and
* limitations under the License.
* SPDX-License-Identifier: Apache-2.0
*==========================================================================
* cmomf_shorted.gds: two caps, the first with its two plates tied together by a
* Metal5 wire drawn outside the marker.
*
* The two combs of a cap_cmomf are kept apart by nothing but their own via
* stacks and the per-metal pin connect in cap_cmomf_connections.lvs, so one
* wire from the PLUS bar to the MINUS edge collapses the device onto a single
* net.
*
* Expected to FAIL, but not on the short itself: KLayout drops a device whose
* terminals all land on the same net, so the shorted cap does not appear in the
* extracted netlist at all and the run fails on the device count. Worth knowing
* before reading a log, because a shorted capacitor reports as a missing one.
.SUBCKT cmomf_shorted
C1 P1 M1 cap_cmomf w=5e-06 l=5e-06 mmin=1 mmax=5
C2 P2 M2 cap_cmomf w=5e-06 l=5e-06 mmin=1 mmax=5
.ENDS cmomf_shorted
