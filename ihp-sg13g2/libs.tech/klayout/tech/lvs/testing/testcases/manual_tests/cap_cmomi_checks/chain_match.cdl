*==========================================================================
* Copyright 2026 IHP PDK Authors
*
* Licensed under the Apache License, Version 2.0 (the "License");
* you may not use this file except in compliance with the License.
* You may obtain a copy of the License at
*
*    https://www.apache.org/licenses/LICENSE-2.0
*
* Unless required by applicable law or agreed to in writing, software
* distributed under the License is distributed on an "AS IS" BASIS,
* WITHOUT WARRANTIES OR CONDITIONS OF ANY KIND, either express or implied.
* See the License for the specific language governing permissions and
* limitations under the License.
* SPDX-License-Identifier: Apache-2.0
*==========================================================================
* Golden netlist for cmomi_chain.gds: three caps in series, A-N1-N2-B.
*
* The shared nodes are what give this case its teeth. With three floating
* caps every net is interchangeable and the compare can relabel its way out
* of almost any netlist error; here N1 and N2 each carry two terminals, so
* the nets are distinguishable and a perturbation has nowhere to hide.
.SUBCKT cmomi_chain
C1 A  N1 cap_cmomi w=5e-06 l=5e-06 mmin=1 mmax=5 feed=double
C2 N1 N2 cap_cmomi w=5e-06 l=5e-06 mmin=1 mmax=5 feed=double
C3 N2 B  cap_cmomi w=5e-06 l=5e-06 mmin=1 mmax=5 feed=double
.ENDS cmomi_chain
