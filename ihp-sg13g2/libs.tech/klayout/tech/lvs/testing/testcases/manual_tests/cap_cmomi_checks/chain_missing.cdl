*==========================================================================
* Copyright 2026 IHP PDK Authors
*
* Licensed under the Apache License, Version 2.0 (the "License");
* you may not use this file except in compliance with the License.
* You may obtain a copy of the License at
*
*    https://www.apache.org/licenses/LICENSE-2.0
*
* Unless required by applicable law or agreed to in writing, software
* distributed under the License is distributed on an "AS IS" BASIS,
* WITHOUT WARRANTIES OR CONDITIONS OF ANY KIND, either express or implied.
* See the License for the specific language governing permissions and
* limitations under the License.
* SPDX-License-Identifier: Apache-2.0
*==========================================================================
* cmomi_chain.gds with one cap missing from the netlist.
*
* Baseline sanity: the deck must notice a device that is present in the layout
* and absent from the schematic. If this ever passes, nothing else in this
* suite means anything.
.SUBCKT cmomi_chain
C1 A  N1 cap_cmomi w=5e-06 l=5e-06 mmin=1 mmax=5 feed=double
C2 N1 B  cap_cmomi w=5e-06 l=5e-06 mmin=1 mmax=5 feed=double
.ENDS cmomi_chain
