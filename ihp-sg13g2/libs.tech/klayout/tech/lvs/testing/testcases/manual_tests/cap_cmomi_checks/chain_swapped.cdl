*==========================================================================
* Copyright 2026 IHP PDK Authors
*
* Licensed under the Apache License, Version 2.0 (the "License");
* you may not use this file except in compliance with the License.
* You may obtain a copy of the License at
*
*    https://www.apache.org/licenses/LICENSE-2.0
*
* Unless required by applicable law or agreed to in writing, software
* distributed under the License is distributed on an "AS IS" BASIS,
* WITHOUT WARRANTIES OR CONDITIONS OF ANY KIND, either express or implied.
* See the License for the specific language governing permissions and
* limitations under the License.
* SPDX-License-Identifier: Apache-2.0
*==========================================================================
* cmomi_chain.gds with the middle cap's two terminals exchanged.
*
* The connectivity graph is identical to chain_match; only the order of two net
* names on one C-line differs. The extractor picks the two ports by geometry and
* never reads their pin names, so the order it produces carries no information:
* for 'double' it follows the instance orientation, and for 'same' the metal
* index decides and puts the PCell's MINUS on pin 1. DeviceCustomMIM therefore
* declares the cap_cmomi terminals equivalent.
*
* Expected to PASS. Before that equivalence this failed, which meant a mirrored
* placement of a mirror-symmetric device was reported as a mismatch.
.SUBCKT cmomi_chain
C1 A  N1 cap_cmomi w=5e-06 l=5e-06 mmin=1 mmax=5 feed=double
C2 N2 N1 cap_cmomi w=5e-06 l=5e-06 mmin=1 mmax=5 feed=double
C3 N2 B  cap_cmomi w=5e-06 l=5e-06 mmin=1 mmax=5 feed=double
.ENDS cmomi_chain
