*==========================================================================
* Copyright 2026 IHP PDK Authors
*
* Licensed under the Apache License, Version 2.0 (the "License");
* you may not use this file except in compliance with the License.
* You may obtain a copy of the License at
*
*    https://www.apache.org/licenses/LICENSE-2.0
*
* Unless required by applicable law or agreed to in writing, software
* distributed under the License is distributed on an "AS IS" BASIS,
* WITHOUT WARRANTIES OR CONDITIONS OF ANY KIND, either express or implied.
* See the License for the specific language governing permissions and
* limitations under the License.
* SPDX-License-Identifier: Apache-2.0
*==========================================================================
* cmomi_chain.gds against the wrong metal band.
*
* The layout is built on mmin=1..mmax=5; this declares mmin=4..mmax=5. Both
* bands put their pins on Metal5 and give the same footprint and the same
* Recog.mom bounding box, so the extractor cannot tell them apart: only the
* number of comb layers differs, and nothing in the deck looks at that. Per the
* PCell's AREACAP table the layer-count densities are 1.36 for N=5 and 0.55 for
* N=2, so the declared device would hold roughly 2.5x less capacitance than the
* one actually drawn.
*
* Expected to PASS. This is the finding with the most consequence for real
* layout: a cap_cmomi built on the wrong metal band is invisible to LVS.
.SUBCKT cmomi_chain
C1 A  N1 cap_cmomi w=5e-06 l=5e-06 mmin=4 mmax=5 feed=double
C2 N1 N2 cap_cmomi w=5e-06 l=5e-06 mmin=4 mmax=5 feed=double
C3 N2 B  cap_cmomi w=5e-06 l=5e-06 mmin=4 mmax=5 feed=double
.ENDS cmomi_chain
