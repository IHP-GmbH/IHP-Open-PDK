*==========================================================================
* Copyright 2026 IHP PDK Authors
*
* Licensed under the Apache License, Version 2.0 (the "License");
* you may not use this file except in compliance with the License.
* You may obtain a copy of the License at
*
*    https://www.apache.org/licenses/LICENSE-2.0
*
* Unless required by applicable law or agreed to in writing, software
* distributed under the License is distributed on an "AS IS" BASIS,
* WITHOUT WARRANTIES OR CONDITIONS OF ANY KIND, either express or implied.
* See the License for the specific language governing permissions and
* limitations under the License.
* SPDX-License-Identifier: Apache-2.0
*==========================================================================
* cmomi_chain.gds against the wrong feed style.
*
* The layout is 'double'; this declares 'same'. feed reaches the reader and is
* then dropped, so the two are indistinguishable to the compare even though a
* 'same' feed adds Cfeed and puts the plates on different metals.
* Expected to PASS, for the same reason as chain_wrong_band.
.SUBCKT cmomi_chain
C1 A  N1 cap_cmomi w=5e-06 l=5e-06 mmin=1 mmax=5 feed=same
C2 N1 N2 cap_cmomi w=5e-06 l=5e-06 mmin=1 mmax=5 feed=same
C3 N2 B  cap_cmomi w=5e-06 l=5e-06 mmin=1 mmax=5 feed=same
.ENDS cmomi_chain
