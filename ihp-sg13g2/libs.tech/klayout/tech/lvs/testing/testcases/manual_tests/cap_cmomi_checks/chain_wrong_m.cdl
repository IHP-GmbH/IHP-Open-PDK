*==========================================================================
* Copyright 2026 IHP PDK Authors
*
* Licensed under the Apache License, Version 2.0 (the "License");
* you may not use this file except in compliance with the License.
* You may obtain a copy of the License at
*
*    https://www.apache.org/licenses/LICENSE-2.0
*
* Unless required by applicable law or agreed to in writing, software
* distributed under the License is distributed on an "AS IS" BASIS,
* WITHOUT WARRANTIES OR CONDITIONS OF ANY KIND, either express or implied.
* See the License for the specific language governing permissions and
* limitations under the License.
* SPDX-License-Identifier: Apache-2.0
*==========================================================================
* cmomi_chain.gds with a multiplier the layout does not have.
*
* Each cap is placed once, so the layout side carries m=1. This declares m=2 on
* all three, i.e. six devices' worth of capacitance against three placements.
*
* Expected to PASS. DeviceCustomMIM declares m with is_primary=true, so it looks
* like a compared parameter, but a wrong m still matches: the SPICE reader takes
* m as the standard SPICE device multiplier rather than mapping it onto the
* class parameter of the same name. m is also the one token beyond w/l that the
* xschem symbol's lvs_format emits, which is why it is worth recording.
.SUBCKT cmomi_chain
C1 A  N1 cap_cmomi w=5e-06 l=5e-06 mmin=1 mmax=5 feed=double m=2
C2 N1 N2 cap_cmomi w=5e-06 l=5e-06 mmin=1 mmax=5 feed=double m=2
C3 N2 B  cap_cmomi w=5e-06 l=5e-06 mmin=1 mmax=5 feed=double m=2
.ENDS cmomi_chain
