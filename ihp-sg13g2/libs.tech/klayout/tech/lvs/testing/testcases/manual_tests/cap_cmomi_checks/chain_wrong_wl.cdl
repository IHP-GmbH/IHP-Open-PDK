*==========================================================================
* Copyright 2026 IHP PDK Authors
*
* Licensed under the Apache License, Version 2.0 (the "License");
* you may not use this file except in compliance with the License.
* You may obtain a copy of the License at
*
*    https://www.apache.org/licenses/LICENSE-2.0
*
* Unless required by applicable law or agreed to in writing, software
* distributed under the License is distributed on an "AS IS" BASIS,
* WITHOUT WARRANTIES OR CONDITIONS OF ANY KIND, either express or implied.
* See the License for the specific language governing permissions and
* limitations under the License.
* SPDX-License-Identifier: Apache-2.0
*==========================================================================
* cmomi_chain.gds against grossly wrong w and l.
*
* The layout is 5x5 um; this declares 99x1 um. DeviceCustomMIM adds w and l
* with is_primary=false, so neither is compared, and the extractor's own values
* are the marker bounding box (5.09u x 6u here) rather than the nominal 5x5
* anyway. Expected to PASS: it pins down the parameter blindness so that adding
* a comparison later shows up as a verdict change instead of going unnoticed.
.SUBCKT cmomi_chain
C1 A  N1 cap_cmomi w=99e-06 l=1e-06 mmin=1 mmax=5 feed=double
C2 N1 N2 cap_cmomi w=99e-06 l=1e-06 mmin=1 mmax=5 feed=double
C3 N2 B  cap_cmomi w=99e-06 l=1e-06 mmin=1 mmax=5 feed=double
.ENDS cmomi_chain
