*==========================================================================
* Copyright 2026 IHP PDK Authors
*
* Licensed under the Apache License, Version 2.0 (the "License");
* you may not use this file except in compliance with the License.
* You may obtain a copy of the License at
*
*    https://www.apache.org/licenses/LICENSE-2.0
*
* Unless required by applicable law or agreed to in writing, software
* distributed under the License is distributed on an "AS IS" BASIS,
* WITHOUT WARRANTIES OR CONDITIONS OF ANY KIND, either express or implied.
* See the License for the specific language governing permissions and
* limitations under the License.
* SPDX-License-Identifier: Apache-2.0
*==========================================================================
* cmomi_feed_none.gds: a feed='none' array declared as a normal cap.
*
* With feed='none' the PCell draws bars and teeth but no feed structure, so the
* alternating rows are never tied into two plates. The two MkPins are still
* emitted, so the marker holds exactly two ports and the extractor builds an
* ordinary cap_cmomi from whatever two bars those pins happen to land on.
*
* Expected to PASS, which is the point: an incomplete structure that is not a
* usable capacitor is accepted as one.
.SUBCKT cmomi_feed_none
C1 PLUS MINUS cap_cmomi w=5e-06 l=5e-06 mmin=1 mmax=5 feed=none
.ENDS cmomi_feed_none
