*==========================================================================
* Copyright 2026 IHP PDK Authors
*
* Licensed under the Apache License, Version 2.0 (the "License");
* you may not use this file except in compliance with the License.
* You may obtain a copy of the License at
*
*    https://www.apache.org/licenses/LICENSE-2.0
*
* Unless required by applicable law or agreed to in writing, software
* distributed under the License is distributed on an "AS IS" BASIS,
* WITHOUT WARRANTIES OR CONDITIONS OF ANY KIND, either express or implied.
* See the License for the specific language governing permissions and
* limitations under the License.
* SPDX-License-Identifier: Apache-2.0
*==========================================================================
* cmomi_merged.gds: two caps sharing one merged Recog.mom marker, next to a
* well formed cap.
*
* Two markers that touch become a single device cluster with four pin ports,
* and CapMomExtractor takes its ports.size != 2 branch and skips the cluster,
* so both of those caps disappear. Only the third one is extracted.
*
* Expected to end in an extraction ERROR. The extractor cannot tell which pins
* belong to which device, so it reports error() naming the marker and KLayout
* raises instead of running the comparison. The partial extracted netlist that
* is still written holds only C3. Previously this was a logger.info line and the
* two devices simply went missing with no verdict change.
.SUBCKT cmomi_merged
C1 P1 M1 cap_cmomi w=5e-06 l=5e-06 mmin=1 mmax=5 feed=double
C2 P2 M2 cap_cmomi w=5e-06 l=5e-06 mmin=1 mmax=5 feed=double
C3 P3 M3 cap_cmomi w=5e-06 l=5e-06 mmin=1 mmax=5 feed=double
.ENDS cmomi_merged
