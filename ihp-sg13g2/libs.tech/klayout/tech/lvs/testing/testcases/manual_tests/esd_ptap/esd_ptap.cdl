** diodevdd_2kv + ptap1 Test

.subckt esd_ptap VSS VDD PAD
*.PININFO VSS:B VDD:B PAD:B
R1 VSS sub! ptap1 A=42.3072e-12 P=0.17628e-03
D1 VDD PAD VSS diodevdd_2kv m=1
.ends
