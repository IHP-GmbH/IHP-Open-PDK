************************************************************************
* Manual SVS testcase: connection mismatch
************************************************************************

.SUBCKT svs_inv A VDD VSS Y
MX1 Y Y VSS VSS sg13_lv_nmos m=1 w=740n l=130n ng=1
MX0 Y A VDD VDD sg13_lv_pmos m=1 w=1.12u l=130n ng=1
.ENDS
