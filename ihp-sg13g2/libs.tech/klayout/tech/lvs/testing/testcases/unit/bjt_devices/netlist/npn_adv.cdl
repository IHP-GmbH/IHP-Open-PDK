*==========================================================================
* Copyright 2024 IHP PDK Authors
*
* Licensed under the Apache License, Version 2.0 (the "License");
* you may not use this file except in compliance with the License.
* You may obtain a copy of the License at
*
*    https://www.apache.org/licenses/LICENSE-2.0
*
* Unless required by applicable law or agreed to in writing, software
* distributed under the License is distributed on an "AS IS" BASIS,
* WITHOUT WARRANTIES OR CONDITIONS OF ANY KIND, either express or implied.
* See the License for the specific language governing permissions and
* limitations under the License.
* SPDX-License-Identifier: Apache-2.0
*==========================================================================

.SUBCKT npn_adv

* Multi Emitters
Q1 C1 B1 E1 sub! npn13G2  le=900.0n we=70.00n  Nx=2 m=1
Q2 C2 B2 E2 sub! npn13G2l le=2.0u   we=70.00n  Nx=3 m=1
Q3 C3 B3 E3 sub! npn13G2  le=900.0n we=70.00n  Nx=5 m=1
Q4 C4 B4 E4 sub! npn13G2v le=3.0u   we=120.00n Nx=7 m=1
Q5 C5 B5 E5 sub! npn13G2  le=900.0n we=70.00n  Nx=8 m=1
Q6 C6 B6 E6 sub! npn13G2  le=900.0n we=70.00n  Nx=10 m=1

* Multi devices with single emitter
Q7 C7 B7 E7 sub! npn13G2l le=1.0u   we=70.00n Nx=1 m=2
Q8 C8 B8 E8 sub! npn13G2l le=2.5u we=70.00n Nx=1 m=4

* Multi devices with multiple emitters
Q9 C9 B9 E9 sub! npn13G2v le=1.0u we=120.00n Nx=2 m=2
Q10 C10 B10 E10 sub! npn13G2v le=5.0u we=120.00n Nx=4 m=3

.ENDS
