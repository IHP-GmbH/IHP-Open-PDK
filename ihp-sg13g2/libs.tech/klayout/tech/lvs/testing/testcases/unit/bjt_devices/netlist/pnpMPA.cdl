*==========================================================================
* Copyright 2024 IHP PDK Authors
*
* Licensed under the Apache License, Version 2.0 (the "License");
* you may not use this file except in compliance with the License.
* You may obtain a copy of the License at
*
*    https://www.apache.org/licenses/LICENSE-2.0
*
* Unless required by applicable law or agreed to in writing, software
* distributed under the License is distributed on an "AS IS" BASIS,
* WITHOUT WARRANTIES OR CONDITIONS OF ANY KIND, either express or implied.
* See the License for the specific language governing permissions and
* limitations under the License.
* SPDX-License-Identifier: Apache-2.0
*==========================================================================

.SUBCKT pnpMPA
Q1 sub net1 net2 pnpMPA a=1.4p p=5.4u  m=1
Q2 sub net3 net4 pnpMPA a=1.5p p=5.5u  m=1
Q3 sub net5 net6 pnpMPA a=1.365p p=5.3u m=1
Q4 sub net7 net8 pnpMPA a=1.4p p=5.4u  m=3

* Extra patterns
Q_pattern_1  sub b_1  e_1  pnpMPA a=40.2752p p=27.96u
Q_pattern_2  sub b_2  e_2  pnpMPA a=18.9281p p=23.64u
Q_pattern_3  sub b_3  e_3  pnpMPA a=75.774p p=34.82u
Q_pattern_4  sub b_4  e_4  pnpMPA a=35.7826p p=25.3u
Q_pattern_5  sub b_5  e_5  pnpMPA a=20.7872p p=21.36u
Q_pattern_6  sub b_6  e_6  pnpMPA a=4.0222p p=9.14u
Q_pattern_7  sub b_7  e_7  pnpMPA a=41.86p p=25.96u
Q_pattern_8  sub b_8  e_8  pnpMPA a=75.48p p=34.76u
Q_pattern_9  sub b_9  e_9  pnpMPA a=62.16p p=31.76u
Q_pattern_10 sub b_10 e_10 pnpMPA a=20.2124p p=18.72u
Q_pattern_11 sub b_11 e_11 pnpMPA a=9.6628p p=18.62u
Q_pattern_12 sub b_12 e_12 pnpMPA a=10.9312p p=13.66u
Q_pattern_13 sub b_13 e_13 pnpMPA a=72.487p p=34.06u
Q_pattern_14 sub b_14 e_14 pnpMPA a=86.8116p p=37.34u
Q_pattern_15 sub b_15 e_15 pnpMPA a=7.7546p p=11.94u
Q_pattern_16 sub b_16 e_16 pnpMPA a=84.32p p=36.84u
Q_pattern_17 sub b_17 e_17 pnpMPA a=69.44p p=33.84u
Q_pattern_18 sub b_18 e_18 pnpMPA a=6.4558p p=10.58u
Q_pattern_19 sub b_19 e_19 pnpMPA a=71.1312p p=33.76u
Q_pattern_20 sub b_20 e_20 pnpMPA a=71.23p p=33.76u
Q_pattern_21 sub b_21 e_21 pnpMPA a=10.3936p p=13.24u
Q_pattern_22 sub b_22 e_22 pnpMPA a=11.7929p p=22.2u
Q_pattern_23 sub b_23 e_23 pnpMPA a=51.727p p=29.26u
Q_pattern_24 sub b_24 e_24 pnpMPA a=37.9176p p=26.3u
Q_pattern_25 sub b_25 e_25 pnpMPA a=76.812p p=35.06u
Q_pattern_26 sub b_26 e_26 pnpMPA a=59.2618p p=31.78u
Q_pattern_27 sub b_27 e_27 pnpMPA a=4.8314p p=10.5u
Q_pattern_28 sub b_28 e_28 pnpMPA a=21.76p p=22.12u
Q_pattern_29 sub b_29 e_29 pnpMPA a=58.66p p=30.76u
Q_pattern_30 sub b_30 e_30 pnpMPA a=29.6088p p=24.28u
Q_pattern_31 sub b_31 e_31 pnpMPA a=8.1557p p=12.36u
Q_pattern_32 sub b_32 e_32 pnpMPA a=80.5504p p=36.08u
Q_pattern_33 sub b_33 e_33 pnpMPA a=42.3584p p=28.38u
Q_pattern_34 sub b_34 e_34 pnpMPA a=16.5215p p=21.12u
Q_pattern_35 sub b_35 e_35 pnpMPA a=61.32p p=31.52u
Q_pattern_36 sub b_36 e_36 pnpMPA a=34.0228p p=24.88u
Q_pattern_37 sub b_37 e_37 pnpMPA a=8.6528p p=11.88u
Q_pattern_38 sub b_38 e_38 pnpMPA a=10.115p p=19.38u
Q_pattern_39 sub b_39 e_39 pnpMPA a=48.5576p p=28.2u
Q_pattern_40 sub b_40 e_40 pnpMPA a=88.0008p p=37.58u
Q_pattern_41 sub b_41 e_41 pnpMPA a=72.1056p p=34u
Q_pattern_42 sub b_42 e_42 pnpMPA a=24.2788p p=20.08u
Q_pattern_43 sub b_43 e_43 pnpMPA a=5.0813p p=10.92u
Q_pattern_44 sub b_44 e_44 pnpMPA a=17.92p p=19.12u
Q_pattern_45 sub b_45 e_45 pnpMPA a=83.0458p p=36.58u
Q_pattern_46 sub b_46 e_46 pnpMPA a=74.46p p=34.52u
Q_pattern_47 sub b_47 e_47 pnpMPA a=16.235p p=20.82u
Q_pattern_48 sub b_48 e_48 pnpMPA a=33.5296p p=26.6u
Q_pattern_49 sub b_49 e_49 pnpMPA a=85.808p p=37.14u
Q_pattern_50 sub b_50 e_50 pnpMPA a=15.5092p p=20.06u
Q_pattern_51 sub b_51 e_51 pnpMPA a=37.4052p p=26.06u
Q_pattern_52 sub b_52 e_52 pnpMPA a=28.3244p p=23.52u
Q_pattern_53 sub b_53 e_53 pnpMPA a=22.144p p=22.42u
Q_pattern_54 sub b_54 e_54 pnpMPA a=8.33p p=16.38u
Q_pattern_55 sub b_55 e_55 pnpMPA a=25.5346p p=20.5u
Q_pattern_56 sub b_56 e_56 pnpMPA a=36.0528p p=25.88u
Q_pattern_57 sub b_57 e_57 pnpMPA a=30.0144p p=24.52u
Q_pattern_58 sub b_58 e_58 pnpMPA a=50.83p p=28.96u
Q_pattern_59 sub b_59 e_59 pnpMPA a=10.2935p p=19.68u
Q_pattern_60 sub b_60 e_60 pnpMPA a=25.3696p p=24.94u
Q_pattern_61 sub b_61 e_61 pnpMPA a=68.0456p p=33u
Q_pattern_62 sub b_62 e_62 pnpMPA a=35.5656p p=25.64u
Q_pattern_63 sub b_63 e_63 pnpMPA a=13.37p p=17.82u
Q_pattern_64 sub b_64 e_64 pnpMPA a=98.3072p p=39.66u
Q_pattern_65 sub b_65 e_65 pnpMPA a=58.66p p=30.76u
Q_pattern_66 sub b_66 e_66 pnpMPA a=10.115p p=19.38u
.ENDS
