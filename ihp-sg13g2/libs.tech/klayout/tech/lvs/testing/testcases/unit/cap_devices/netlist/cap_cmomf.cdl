*==========================================================================
* Copyright 2026 IHP PDK Authors
*
* Licensed under the Apache License, Version 2.0 (the "License");
* you may not use this file except in compliance with the License.
* You may obtain a copy of the License at
*
*    https://www.apache.org/licenses/LICENSE-2.0
*
* Unless required by applicable law or agreed to in writing, software
* distributed under the License is distributed on an "AS IS" BASIS,
* WITHOUT WARRANTIES OR CONDITIONS OF ANY KIND, either express or implied.
* See the License for the specific language governing permissions and
* limitations under the License.
* SPDX-License-Identifier: Apache-2.0
*==========================================================================
* Covers both orientations of the top metal of cap_cmomf on the g2
* Metal1..Metal5 stack, and a stack that does not reach the top metal. The
* finger direction alternates per layer, so the metal that carries the
* PLUS/MINUS pins depends on how many layers the stack has:
*   C1 = M1..M5 -> the top metal's fingers run along Y, pins land on the left
*                  edge and the top connecting bar
*   C2 = M2..M5 -> the top metal's fingers run along X, pins land on the left
*                  connecting bar and the top edge
*   C3 = M1..M3 -> the ports come off Metal3, which is the only way the m3 port
*                  path of the extractor is reached
*
* Layout generated by create_cap_cmomf_testcases.py.
.SUBCKT cap_cmomf
C1 P1 M1 cap_cmomf w=5e-06 l=5e-06 mmin=1 mmax=5
C2 P2 M2 cap_cmomf w=5e-06 l=5e-06 mmin=2 mmax=5
C3 P3 M3 cap_cmomf w=5e-06 l=5e-06 mmin=1 mmax=3
.ENDS cap_cmomf
