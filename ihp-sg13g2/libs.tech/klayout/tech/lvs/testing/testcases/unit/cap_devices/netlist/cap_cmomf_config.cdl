*==========================================================================
* Copyright 2026 IHP PDK Authors
*
* Licensed under the Apache License, Version 2.0 (the "License");
* you may not use this file except in compliance with the License.
* You may obtain a copy of the License at
*
*    https://www.apache.org/licenses/LICENSE-2.0
*
* Unless required by applicable law or agreed to in writing, software
* distributed under the License is distributed on an "AS IS" BASIS,
* WITHOUT WARRANTIES OR CONDITIONS OF ANY KIND, either express or implied.
* See the License for the specific language governing permissions and
* limitations under the License.
* SPDX-License-Identifier: Apache-2.0
*==========================================================================
* Configuration matrix for cap_cmomf: one device per PCell configuration, each
* on its own net pair, so the only thing asserted is that every configuration is
* recognised and extracted exactly once.
*
* The bands are chosen for the port layer they land on. The pins always sit on
* the mmax metal, so mmax is the only thing that decides which of the deck's
* m1p..m5p port paths is exercised at all, and all five are covered here.
* mmax=1 also puts them on the 0.16 wide Metal1 bar, the one case where the
* PCell has to clip the pin box to the metal it labels.
*
* Layout generated by create_cap_cmomf_testcases.py.
.SUBCKT cap_cmomf_config
C1 P1 M1 cap_cmomf w=5e-06  l=5e-06  mmin=1 mmax=5
C2 P2 M2 cap_cmomf w=5e-06  l=5e-06  mmin=2 mmax=5
C3 P3 M3 cap_cmomf w=5e-06  l=5e-06  mmin=1 mmax=4
C4 P4 M4 cap_cmomf w=5e-06  l=5e-06  mmin=1 mmax=3
C5 P5 M5 cap_cmomf w=5e-06  l=5e-06  mmin=1 mmax=2
C6 P6 M6 cap_cmomf w=5e-06  l=5e-06  mmin=1 mmax=1
C7 P7 M7 cap_cmomf w=5e-06  l=5e-06  mmin=1 mmax=5
C8 P8 M8 cap_cmomf w=10e-06 l=20e-06 mmin=1 mmax=5
.ENDS cap_cmomf_config
