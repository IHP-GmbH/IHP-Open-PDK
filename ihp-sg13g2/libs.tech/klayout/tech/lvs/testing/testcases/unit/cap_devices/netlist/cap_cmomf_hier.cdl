*==========================================================================
* Copyright 2026 IHP PDK Authors
*
* Licensed under the Apache License, Version 2.0 (the "License");
* you may not use this file except in compliance with the License.
* You may obtain a copy of the License at
*
*    https://www.apache.org/licenses/LICENSE-2.0
*
* Unless required by applicable law or agreed to in writing, software
* distributed under the License is distributed on an "AS IS" BASIS,
* WITHOUT WARRANTIES OR CONDITIONS OF ANY KIND, either express or implied.
* See the License for the specific language governing permissions and
* limitations under the License.
* SPDX-License-Identifier: Apache-2.0
*==========================================================================
* Three caps placed hierarchically: a sub-cell instanced twice plus one direct
* placement of the PCell, none of them connected to anything.
*
* What this asserts is that the same marker geometry appearing under several
* cell instances is extracted once per instance and not once per cell
* definition. The regression runs it in the default flat mode; the checks suite
* runs the same layout in deep, where it comes out empty.
*
* Layout generated by create_cap_cmomf_testcases.py.
.SUBCKT cap_cmomf_hier
C1 P1 M1 cap_cmomf w=5e-06 l=5e-06 mmin=1 mmax=5
C2 P2 M2 cap_cmomf w=5e-06 l=5e-06 mmin=1 mmax=5
C3 P3 M3 cap_cmomf w=5e-06 l=5e-06 mmin=1 mmax=5
.ENDS cap_cmomf_hier
