*==========================================================================
* Copyright 2026 IHP PDK Authors
*
* Licensed under the Apache License, Version 2.0 (the "License");
* you may not use this file except in compliance with the License.
* You may obtain a copy of the License at
*
*    https://www.apache.org/licenses/LICENSE-2.0
*
* Unless required by applicable law or agreed to in writing, software
* distributed under the License is distributed on an "AS IS" BASIS,
* WITHOUT WARRANTIES OR CONDITIONS OF ANY KIND, either express or implied.
* See the License for the specific language governing permissions and
* limitations under the License.
* SPDX-License-Identifier: Apache-2.0
*==========================================================================
* Covers BOTH feed variants of cap_cmomi:
*   C1 = double (opposite-side) feed  -> both pins on the top metal
*   C2 = same   (single-side) feed    -> two pins stacked on adjacent metals,
*                                        kept on distinct nets by per-metal
*                                        pin connectivity (the isolation check)
.SUBCKT cap_cmomi
C1 P1 M1 cap_cmomi w=7e-06 l=7e-06
C2 P2 M2 cap_cmomi w=5e-06 l=5e-06
.ENDS cap_cmomi
