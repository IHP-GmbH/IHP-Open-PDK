*==========================================================================
* Copyright 2026 IHP PDK Authors
*
* Licensed under the Apache License, Version 2.0 (the "License");
* you may not use this file except in compliance with the License.
* You may obtain a copy of the License at
*
*    https://www.apache.org/licenses/LICENSE-2.0
*
* Unless required by applicable law or agreed to in writing, software
* distributed under the License is distributed on an "AS IS" BASIS,
* WITHOUT WARRANTIES OR CONDITIONS OF ANY KIND, either express or implied.
* See the License for the specific language governing permissions and
* limitations under the License.
* SPDX-License-Identifier: Apache-2.0
*==========================================================================
* cap_cmomi instanced through a cell hierarchy.
*
* The layout puts one cap in a sub-cell that is instanced twice, plus a third
* cap placed directly in the top cell. All three carry the same Recog.mom
* marker geometry, so this is what would catch a marker collision or a device
* being extracted once per instance definition instead of once per placement.
* Layout generated by create_cap_cmomi_testcases.py.
*
* Runs in the default flat mode, so the hierarchy is flattened before
* extraction. Deep mode is not exercised here: the deep netlist collapses onto
* the PCell's own subcircuit and simplify drops the top cell, which is generic
* KLayout hierarchy behaviour rather than anything specific to cap_cmomi, and
* test-LVS-switch already covers flat vs deep.
.SUBCKT cap_cmomi_hier
C1 P1 M1 cap_cmomi w=5e-06 l=5e-06 mmin=1 mmax=5 feed=double
C2 P2 M2 cap_cmomi w=5e-06 l=5e-06 mmin=1 mmax=5 feed=double
C3 P3 M3 cap_cmomi w=5e-06 l=5e-06 mmin=1 mmax=5 feed=double
.ENDS cap_cmomi_hier
