*==========================================================================
* Copyright 2024 IHP PDK Authors
*
* Licensed under the Apache License, Version 2.0 (the "License");
* you may not use this file except in compliance with the License.
* You may obtain a copy of the License at
*
*    https://www.apache.org/licenses/LICENSE-2.0
*
* Unless required by applicable law or agreed to in writing, software
* distributed under the License is distributed on an "AS IS" BASIS,
* WITHOUT WARRANTIES OR CONDITIONS OF ANY KIND, either express or implied.
* See the License for the specific language governing permissions and
* limitations under the License.
* SPDX-License-Identifier: Apache-2.0
*==========================================================================
*
* Regression case for IHP-Open-PDK issue #958:
* A cap_cmim placed directly above a schottky_nbl1 diode must still be
* extracted as a regular CMIM. The diode brings a PWellBlock region that
* only partially underlaps the MIM, which previously mis-triggered the
* RFCMIM path and broke the CMIM extraction.

.SUBCKT cmim_sbd test1 test2
*.PININFO test1:B test2:B
DD1 test1 test2 test2 schottky_nbl1
C1 test1 test2 cap_cmim w=10.0e-6 l=10.0e-6
.ENDS
