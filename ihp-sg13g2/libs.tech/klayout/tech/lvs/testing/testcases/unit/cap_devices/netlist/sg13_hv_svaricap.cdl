*==========================================================================
* Copyright 2024 IHP PDK Authors
*
* Licensed under the Apache License, Version 2.0 (the "License");
* you may not use this file except in compliance with the License.
* You may obtain a copy of the License at
*
*    https://www.apache.org/licenses/LICENSE-2.0
*
* Unless required by applicable law or agreed to in writing, software
* distributed under the License is distributed on an "AS IS" BASIS,
* WITHOUT WARRANTIES OR CONDITIONS OF ANY KIND, either express or implied.
* See the License for the specific language governing permissions and
* limitations under the License.
* SPDX-License-Identifier: Apache-2.0
*==========================================================================

.SUBCKT sg13_hv_svaricap

* Note: only two combinations are allowed for sg13_hv_svaricap:
* small (w=3.74u, l=0.3u) and large (w=9.74u, l=0.8u).
* Nx sweep patterns (small: w=3.74u, l=0.3u)
C1_Nx1   G1_Nx1   W_Nx1   G2_Nx1   sub sg13_hv_svaricap l=0.3u w=3.74u Nx=1
C1_Nx2   G1_Nx2   W_Nx2   G2_Nx2   sub sg13_hv_svaricap l=0.3u w=3.74u Nx=2
C1_Nx3   G1_Nx3   W_Nx3   G2_Nx3   sub sg13_hv_svaricap l=0.3u w=3.74u Nx=3
C1_Nx4   G1_Nx4   W_Nx4   G2_Nx4   sub sg13_hv_svaricap l=0.3u w=3.74u Nx=4
C1_Nx5   G1_Nx5   W_Nx5   G2_Nx5   sub sg13_hv_svaricap l=0.3u w=3.74u Nx=5
C1_Nx6   G1_Nx6   W_Nx6   G2_Nx6   sub sg13_hv_svaricap l=0.3u w=3.74u Nx=6
C1_Nx7   G1_Nx7   W_Nx7   G2_Nx7   sub sg13_hv_svaricap l=0.3u w=3.74u Nx=7
C1_Nx8   G1_Nx8   W_Nx8   G2_Nx8   sub sg13_hv_svaricap l=0.3u w=3.74u Nx=8
C1_Nx9   G1_Nx9   W_Nx9   G2_Nx9   sub sg13_hv_svaricap l=0.3u w=3.74u Nx=9
C1_Nx10  G1_Nx10  W_Nx10  G2_Nx10  sub sg13_hv_svaricap l=0.3u w=3.74u Nx=10

* Nx sweep patterns (large: w=9.74u, l=0.8u)
C2_Nx1   G1L_Nx1   WL_Nx1   G2L_Nx1   sub sg13_hv_svaricap l=0.8u w=9.74u Nx=1
C2_Nx2   G1L_Nx2   WL_Nx2   G2L_Nx2   sub sg13_hv_svaricap l=0.8u w=9.74u Nx=2
C2_Nx3   G1L_Nx3   WL_Nx3   G2L_Nx3   sub sg13_hv_svaricap l=0.8u w=9.74u Nx=3
C2_Nx4   G1L_Nx4   WL_Nx4   G2L_Nx4   sub sg13_hv_svaricap l=0.8u w=9.74u Nx=4
C2_Nx5   G1L_Nx5   WL_Nx5   G2L_Nx5   sub sg13_hv_svaricap l=0.8u w=9.74u Nx=5
C2_Nx6   G1L_Nx6   WL_Nx6   G2L_Nx6   sub sg13_hv_svaricap l=0.8u w=9.74u Nx=6
C2_Nx7   G1L_Nx7   WL_Nx7   G2L_Nx7   sub sg13_hv_svaricap l=0.8u w=9.74u Nx=7
C2_Nx8   G1L_Nx8   WL_Nx8   G2L_Nx8   sub sg13_hv_svaricap l=0.8u w=9.74u Nx=8
C2_Nx9   G1L_Nx9   WL_Nx9   G2L_Nx9   sub sg13_hv_svaricap l=0.8u w=9.74u Nx=9
C2_Nx10  G1L_Nx10  WL_Nx10  G2L_Nx10  sub sg13_hv_svaricap l=0.8u w=9.74u Nx=10

* TEST parallel varicap
C1 G1_1 W1 G2_1 sub sg13_hv_svaricap W=3.74e-6 L=0.3e-6 Nx=1
C2 G1_1 W1 G2_1 sub sg13_hv_svaricap W=3.74e-6 L=0.3e-6 Nx=1

C3 G1_2 W2 G2_2 sub sg13_hv_svaricap W=3.74e-6 L=0.3e-6 Nx=2
C4 G1_2 W2 G2_2 sub sg13_hv_svaricap W=3.74e-6 L=0.3e-6 Nx=4

C5 G1_3 W3 G2_3 sub sg13_hv_svaricap W=3.74e-6 L=0.3e-6 Nx=3
C6 G1_3 W3 G2_3 sub sg13_hv_svaricap W=3.74e-6 L=0.3e-6 Nx=5
C7 G1_3 W3 G2_3 sub sg13_hv_svaricap W=3.74e-6 L=0.3e-6 Nx=7

.ENDS
