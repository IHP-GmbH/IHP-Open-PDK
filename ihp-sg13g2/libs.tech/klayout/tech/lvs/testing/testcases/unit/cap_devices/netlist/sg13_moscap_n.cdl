*==========================================================================
* Copyright 2026 IHP PDK Authors
*
* Licensed under the Apache License, Version 2.0 (the "License");
* you may not use this file except in compliance with the License.
* You may obtain a copy of the License at
*
*    https://www.apache.org/licenses/LICENSE-2.0
*
* Unless required by applicable law or agreed to in writing, software
* distributed under the License is distributed on an "AS IS" BASIS,
* WITHOUT WARRANTIES OR CONDITIONS OF ANY KIND, either express or implied.
* See the License for the specific language governing permissions and
* limitations under the License.
* SPDX-License-Identifier: Apache-2.0
*==========================================================================

.SUBCKT sg13_moscap_n

* w/l sweep
C1 G1 SUB1 sg13_moscap_n w=1u l=1u
C2 G2 SUB2 sg13_moscap_n w=5u l=1u
C3 G3 SUB3 sg13_moscap_n w=10u l=5u
C4 G4 SUB4 sg13_moscap_n w=5u l=1u

* parallel test
C5 G5 SUB5 sg13_moscap_n w=5u l=1u
C6 G6 SUB6 sg13_moscap_n w=5u l=1u

.ENDS
