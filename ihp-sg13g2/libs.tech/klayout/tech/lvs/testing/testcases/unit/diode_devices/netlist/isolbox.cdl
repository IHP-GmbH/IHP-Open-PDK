** INMOS - (Testing Isolbox)

.subckt inmos D G S nwell
*.PININFO D:B G:B S:B nwell:B
M1 D G S isosub sg13_lv_nmos w=0.15u l=0.13u ng=1 m=1
R1 S isosub ptap1 A=6.084e-13 P=3.12e-06
D1 isosub nwell sub! isolbox l=6.0u w=6.0u
.ends
.GLOBAL sub!
.end
