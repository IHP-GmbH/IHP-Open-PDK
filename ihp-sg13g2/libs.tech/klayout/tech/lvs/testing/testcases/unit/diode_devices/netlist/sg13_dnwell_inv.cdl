*==========================================================================
* Copyright 2026 IHP PDK Authors
*
* Licensed under the Apache License, Version 2.0 (the "License");
* you may not use this file except in compliance with the License.
* You may obtain a copy of the License at
*
*    https://www.apache.org/licenses/LICENSE-2.0
*
* Unless required by applicable law or agreed to in writing, software
* distributed under the License is distributed on an "AS IS" BASIS,
* WITHOUT WARRANTIES OR CONDITIONS OF ANY KIND, either express or implied.
* See the License for the specific language governing permissions and
* limitations under the License.
* SPDX-License-Identifier: Apache-2.0
*==========================================================================
*
* Deep-nwell isolated inverter. The NMOS sits in the isolated pwell with its bulk
* tied to its source; the PMOS well sits on the tub and is biased to VDD through
* the contacted isolbox guard ring. Per DRC rule NBL.d an NWell on nBuLay is
* necessarily the same net as the tub, so the PMOS bulk cannot be at any other
* potential.
*
* Complements test_ptap_dnw_ext (isolated NMOS) by covering a PMOS inside the tub,
* and exercises the isolbox I terminal resolving to a named top-level port, which
* requires the isolbox_tie connection in the LVS deck.

.SUBCKT sg13_dnwell_inv VSS S VDD G D
*.PININFO VSS:B S:B VDD:B G:B D:B
D1 S VDD VSS isolbox l=10.0u w=10.0u
MM1 net1 G D VDD sg13_lv_pmos w=0.15u l=0.13u ng=1
MM2 net1 G S S sg13_lv_nmos w=0.15u l=0.13u ng=1
.ENDS
