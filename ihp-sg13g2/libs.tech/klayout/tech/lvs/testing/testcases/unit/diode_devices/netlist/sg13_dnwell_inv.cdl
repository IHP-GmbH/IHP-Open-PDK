** SG13_DNWELL_INV - deep-nwell isolated inverter (Testing Isolbox)

.SUBCKT sg13_dnwell_inv VSS S VDD G D
*.PININFO VSS:B S:B VDD:B G:B D:B
MM1 net1 G D nw sg13_lv_pmos w=0.15u l=0.13u ng=1 m=1
MM2 net1 G S isopw sg13_lv_nmos w=0.15u l=0.13u ng=1 m=1
D1 isopw VDD sub isolbox l=10.0u w=10.0u
R1 VDD nw ntap1 A=6.084e-13 P=3.12e-06
R2 VSS sub ptap1 A=6.084e-13 P=3.12e-06
R3 S isopw ptap1 A=6.084e-13 P=3.12e-06
.ENDS
