*==========================================================================
* Copyright 2024 IHP PDK Authors
*
* Licensed under the Apache License, Version 2.0 (the "License");
* you may not use this file except in compliance with the License.
* You may obtain a copy of the License at
*
*    https://www.apache.org/licenses/LICENSE-2.0
*
* Unless required by applicable law or agreed to in writing, software
* distributed under the License is distributed on an "AS IS" BASIS,
* WITHOUT WARRANTIES OR CONDITIONS OF ANY KIND, either express or implied.
* See the License for the specific language governing permissions and
* limitations under the License.
* SPDX-License-Identifier: Apache-2.0
*==========================================================================
*
* Deep-mode counterpart of test_ntap_ptap_ext with tap extraction ENABLED
* (the default). The ntap1/ptap1 guard rings sit inside the nmos/pmos subcells,
* so in deep mode they are extracted cell-locally through the cheat-based
* guard-ring extraction (see tap_extraction.lvs / tap_derivations.lvs). This
* case guards that path: the schematic contains the matching tap devices and
* the MOS bulks connect to the well/substrate nets through them.

.SUBCKT test_ntap_ptap_ext_deep VDD VSS vin vout
*.PININFO vin:I VDD:B VSS:B vout:B
MMdummy1 VSS VSS VSS B_SUB sg13_lv_nmos w=2.0u l=1.0u ng=2
MMdummy2 VDD VDD VDD B_WELL sg13_lv_pmos w=12.0u l=1.0u ng=2
MM1 vout vin VSS B_SUB sg13_lv_nmos w=20.0u l=1.0u ng=20
MM2 vout vin VDD B_WELL sg13_lv_pmos w=120.0u l=1.0u ng=20
RT1 VSS B_SUB ptap1 A=21.276p P=141.84u
RT2 VDD B_WELL ntap1 A=24.06p P=160.4u
.ENDS
