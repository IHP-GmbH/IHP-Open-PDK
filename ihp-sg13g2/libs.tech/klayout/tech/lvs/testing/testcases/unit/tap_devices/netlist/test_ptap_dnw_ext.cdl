*==========================================================================
* Copyright 2024 IHP PDK Authors
*
* Licensed under the Apache License, Version 2.0 (the "License");
* you may not use this file except in compliance with the License.
* You may obtain a copy of the License at
*
*    https://www.apache.org/licenses/LICENSE-2.0
*
* Unless required by applicable law or agreed to in writing, software
* distributed under the License is distributed on an "AS IS" BASIS,
* WITHOUT WARRANTIES OR CONDITIONS OF ANY KIND, either express or implied.
* See the License for the specific language governing permissions and
* limitations under the License.
* SPDX-License-Identifier: Apache-2.0
*==========================================================================
*
* Regression case for IHP-Open-PDK issue #955 (--disable_tap_extraction), deep-nwell
* isolated NMOS. The NMOS sits in an isolated pwell with its bulk tied to the source,
* and the isolation is described by an isolbox device. It only matches when tap device
* extraction is disabled (so the isolated pwell ties to the source through the contact).
* It also needs --ignore_top_ports_mismatch because the isolation nwell ring is not
* biased to VDD and the VDD top-level port does not resolve strictly.

.SUBCKT test_ptap_dnw_ext D G S VDD VSS
*.PININFO D:B G:B S:B VDD:B VSS:B
MM1 D G S S sg13_lv_nmos w=0.15u l=0.13u ng=1
D1 S VDD VSS isolbox l=6.0u w=6.0u
.ENDS
.GLOBAL VSS
