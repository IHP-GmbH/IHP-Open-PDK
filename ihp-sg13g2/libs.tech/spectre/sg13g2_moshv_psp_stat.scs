simulator lang=spectre insensitive=yes
*******************************************************************************
*                                                                             *
* Library:      SG13G2_dev                                                    *
* Technologies: SG13G2                                                        *
* Component:    Spectre model file for Spectre 18                             *
*                                                                             *
* Simulator:    Spectre 20.1                                                  *
* Model:        PSP 103.6                                                     *
* Revision:     210511                                                        *
*                                                                             *
*******************************************************************************
*                                                                             *
* Copyright 2023 IHP PDK Authors                                              *
*                                                                             *
* Licensed under the Apache License, Version 2.0 (the "License");             *
* you may not use this file except in compliance with the License.            *
* You may obtain a copy of the License at                                     *
*                                                                             *
*     https://www.apache.org/licenses/LICENSE-2.0                             *
*                                                                             *
* Unless required by applicable law or agreed to in writing, software         *
* distributed under the License is distributed on an "AS IS" BASIS,           *
* WITHOUT WARRANTIES OR CONDITIONS OF ANY KIND, either express or implied.    *
* See the License for the specific language governing permissions and         *
* limitations under the License.                                              *
*                                                                             *
*******************************************************************************
*******************************************************************************
*                                                                             *
*                                                                             *
*                S T A T I S T I C A L    V A R I A T I O N S                 *
*                                                                             *
*                                                                             *
*******************************************************************************
*
*
*
* NOTE: do not use percent=yes option
* values are one-sigma deviations (1/3 of min-max)
*

parameters sg13g2_hv_nmos_vfbo_mm     = 1.0
parameters sg13g2_hv_pmos_vfbo_mm     = 1.0
parameters sg13g2_hv_svaricap_vfbo_mm    = 1.0

statistics {
  process {
    vary sg13g2_hv_nmos_rsgo        dist=gauss  std=1e-9  percent=no
    vary sg13g2_hv_nmos_rsw1        dist=gauss  std=0.0001  percent=no
    vary sg13g2_hv_nmos_mueo        dist=gauss  std=0.0335  percent=no
    vary sg13g2_hv_nmos_dphibo      dist=gauss  std=0.1503  percent=no
    vary sg13g2_hv_nmos_dphibl      dist=gauss  std=0.2052  percent=no
    vary sg13g2_hv_nmos_dphibw      dist=gauss  std=1e-9    percent=no
    vary sg13g2_hv_nmos_dphiblw     dist=gauss  std=0.0151  percent=no
    vary sg13g2_hv_nmos_ctl         dist=gauss  std=1e-9    percent=no
    vary sg13g2_hv_nmos_thesato     dist=gauss  std=1e-9    percent=no
    vary sg13g2_hv_nmos_thesatl     dist=gauss  std=0.0358  percent=no
    vary sg13g2_hv_nmos_thesatw     dist=gauss  std=1e-9    percent=no
    vary sg13g2_hv_nmos_thesatlw    dist=gauss  std=0.0353  percent=no
    vary sg13g2_hv_nmos_toxo        dist=gauss  std=0.0133  percent=no
    vary sg13g2_hv_nmos_toxovo      dist=gauss  std=0.0133  percent=no
    vary sg13g2_hv_nmos_cjorbot     dist=gauss  std=0.0267  percent=no
    vary sg13g2_hv_nmos_cjorsti     dist=gauss  std=0.0267  percent=no
    vary sg13g2_hv_nmos_cjorgat     dist=gauss  std=0.0267  percent=no

    vary sg13g2_hv_pmos_rsgo        dist=gauss  std=0.4253  percent=no
    vary sg13g2_hv_pmos_rsw1        dist=gauss  std=1e-9  percent=no
    vary sg13g2_hv_pmos_mueo        dist=gauss  std=0.0014  percent=no
    vary sg13g2_hv_pmos_dphibo      dist=gauss  std=0.0572  percent=no
    vary sg13g2_hv_pmos_dphibl      dist=gauss  std=0.0672  percent=no
    vary sg13g2_hv_pmos_dphibw      dist=gauss  std=0.0183  percent=no
    vary sg13g2_hv_pmos_dphiblw     dist=gauss  std=1.0138  percent=no
    vary sg13g2_hv_pmos_bgidlo      dist=gauss  std=0.1538  percent=no
    vary sg13g2_hv_pmos_thesato     dist=gauss  std=1e-9  percent=no
    vary sg13g2_hv_pmos_thesatl     dist=gauss  std=0.0198  percent=no
    vary sg13g2_hv_pmos_thesatw     dist=gauss  std=0.4367  percent=no
    vary sg13g2_hv_pmos_thesatlw    dist=gauss  std=1e-9  percent=no
    vary sg13g2_hv_pmos_csl         dist=gauss  std=1e-9  percent=no
    vary sg13g2_hv_pmos_toxo        dist=gauss  std=0.0133  percent=no
    vary sg13g2_hv_pmos_toxovo      dist=gauss  std=0.0133  percent=no
    vary sg13g2_hv_pmos_cjorbot     dist=gauss  std=0.0267  percent=no
    vary sg13g2_hv_pmos_cjorsti     dist=gauss  std=0.0267  percent=no
    vary sg13g2_hv_pmos_cjorgat     dist=gauss  std=0.0267  percent=no

    vary sg13g2_hv_svaricap_lap       dist=gauss  std=0.067 percent=no
    vary sg13g2_hv_svaricap_toxo      dist=gauss  std=0.013 percent=no
  }
  mismatch {
    vary sg13g2_hv_nmos_vfbo_mm     dist=gauss  std=0.0078 percent=no

    vary sg13g2_hv_pmos_vfbo_mm     dist=gauss  std=0.0058 percent=no

    vary sg13g2_hv_svaricap_vfbo_mm    dist=gauss  std=0.0001 percent=no
  }
  truncate tr=3.0      // +/- 3 sigma

  correlate param=[sg13g2_hv_nmos_dphibo  sg13g2_hv_nmos_toxo]    cc=1
  correlate param=[sg13g2_hv_pmos_dphibo  sg13g2_hv_pmos_toxo]    cc=1

}
